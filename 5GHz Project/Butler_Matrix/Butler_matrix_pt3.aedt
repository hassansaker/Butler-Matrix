# Ansys Electronics Desktop project, version 2018.2
project variables:
  $W_50 = 2.21849mm
  $L_50 = 8.92656mm
  $W_120 = 0.30894mm
  $W_70 = 1.19566mm
  $L_120 = 9.52516mm
materials:
  copper: permeability=0.999991 conductivity=58000000
  FR4_epoxy: permittivity=4.4 dielectric_loss_tangent=0.02
  Rogers RO4003 (tm): permittivity=3.55 dielectric_loss_tangent=0.0027

design Hybrid_WB (Circuit)
options: SParamCircuitDef IntegrationMethod=FFT
components:
  A2 = MS_TRL(W=1.76772mm P=5mm)
  A1 = MS_TRL(W=1.76772mm P=5mm)
  A6 = MS_TEEC(W2=2.98223mm W1=1.76772mm W3=0.24287mm)
  A3 = MS_TEEC(W1=2.98223mm W2=1.76772mm W3=0.24287mm)
  A10 = MS_TRL(W=0.24287mm P=9.55345mm)
  A11 = MS_TRL(W=2.98223mm P=8.73787mm)
  A4 = MS_TRL(W=2.98223mm P=8.73787mm)
  A5 = MS_TEEC(W1=2.98223mm W2=2.98223mm W3=2.98223mm)
  A7 = MS_TEEC(W1=2.98223mm W2=2.98223mm W3=2.98223mm)
  A8 = MS_TRL(W=2.98223mm P=9.55345mm)
  A9 = MS_TRL(W=2.98223mm P=8.73787mm)
  A12 = MS_TRL(W=2.98223mm P=8.73787mm)
  A13 = MS_TEEC(W2=2.98223mm W1=1.76772mm W3=0.24287mm)
  A14 = MS_TEEC(W1=2.98223mm W2=1.76772mm W3=0.24287mm)
  A15 = MS_TRL(W=0.24287mm P=9.55345mm)
  A16 = MS_TRL(W=1.76772mm P=5mm)
  A17 = MS_TRL(W=1.76772mm P=5mm)
  port Port1 pnum=1 rz=50ohm iz=0ohm noisetemp=16.85 noisetemporig=16.85cel
  port Port2 pnum=2 rz=50ohm iz=0ohm noisetemp=16.85 noisetemporig=16.85cel
  port Port3 pnum=3 rz=50ohm iz=0ohm noisetemp=16.85 noisetemporig=16.85cel
  port Port4 pnum=4 rz=50ohm iz=0ohm noisetemp=16.85 noisetemporig=16.85cel
nets:
  net_1: A2.1, A6.0
  net_10: A8.1, A5.2
  net_11: A9.0, A5.1
  net_12: A7.0, A12.0
  net_13: A13.1, A12.1
  net_14: A9.1, A14.0
  net_15: A13.2, A15.0
  net_16: A15.1, A14.2
  net_17: A16.0, A14.1
  net_18: A13.0, A17.0
  net_2: A1.1, A3.1
  net_3: A6.2, A10.1
  net_4: A3.2, A10.0
  net_5: A6.1, A11.0
  net_6: A4.0, A3.0
  net_7: A11.1, A5.0
  net_8: A4.1, A7.1
  net_9: A7.2, A8.0
  Port1: A2.0
  Port2: A16.1
  Port3: A17.1
  Port4: A1.0
setups:
  LinearFrequency: LinearFrequencyData(false, 0.1, false, "", false) SweepDefinition{Variable=F Data="LIN 3GHz 7GHz 0.005GHz"}
output variables:
  phase_diff = abs((mod(abs(cang_rad(S(2,1))-cang_rad(S(3,1))),pi)-(pi/2))*180/pi)
  PortGainDiff = abs(dB(S(Port2,Port1))-dB(S(Port3,Port1)))
reports:
  S-Parameters: dB(S(Port1,Port1)), dB(S(Port2,Port1)), dB(S(Port3,Port1)), dB(S(Port4,Port1)) vs F on LinearFrequency : LinearFrequency; markers MX1 at x=5.0045215e+09, MY1 at y=-14
  Port Gain Difference: PortGainDiff vs F on LinearFrequency : LinearFrequency; markers m1 at 5GHz
  Phase Error: phase_diff vs F on LinearFrequency : LinearFrequency; markers m1 at 5GHz, MY1 at y=2

design Crossover (Circuit)
options: SParamCircuitDef IntegrationMethod=FFT
components:
  A52 = MS_TRL(W=1.76772mm P=5mm)
  A53 = MS_TEEC(W1=1.76772mm W2=1.76772mm W3=1.76772mm)
  A1 = MS_TRL(W=1.76772mm P=8.95112mm)
  A2 = MS_TEEC(W1=1.76772mm W2=1.76772mm W3=1.76772mm)
  A3 = MS_TRL(W=1.76772mm P=5mm)
  A6 = MS_TRL(W=1.76772mm P=8.95112mm)
  A7 = MS_TEEC(W1=1.76772mm W2=1.76772mm W3=1.76772mm)
  A8 = MS_TRL(W=1.76772mm P=8.95112mm)
  A9 = MS_TEEC(W1=1.76772mm W2=1.76772mm W3=1.76772mm)
  A10 = MS_TRL(W=1.76772mm P=8.95112mm)
  A5 = MS_TRL(W=1.76772mm P=5mm)
  A4 = MS_TRL(W=1.76772mm P=5mm)
  A11 = MS_TRL(W=1.76772mm P=8.95112mm)
  A12 = MS_TEEC(W1=1.76772mm W2=1.76772mm W3=1.76772mm)
  A13 = MS_TRL(W=1.76772mm P=8.95112mm)
  A14 = MS_TEEC(W1=1.76772mm W2=1.76772mm W3=1.76772mm)
  A15 = MS_TRL(W=1.76772mm P=8.95112mm)
  port Port1 pnum=1 rz=50ohm iz=0ohm noisetemp=16.85 noisetemporig=16.85cel
  port Port2 pnum=2 rz=50ohm iz=0ohm noisetemp=16.85 noisetemporig=16.85cel
  port Port3 pnum=3 rz=50ohm iz=0ohm noisetemp=16.85 noisetemporig=16.85cel
  port Port4 pnum=4 rz=50ohm iz=0ohm noisetemp=16.85 noisetemporig=16.85cel
nets:
  net_20: A53.0, A52.1
  net_21: A53.2, A1.1
  net_22: A1.0, A2.2
  net_23: A3.1, A2.1
  net_27: A6.0, A2.0
  net_29: A6.1, A7.1
  net_30: A7.2, A8.0
  net_32: A8.1, A9.2
  net_33: A10.0, A53.1
  net_34: A10.1, A9.0
  net_35: A11.0, A7.0
  net_36: A5.0, A12.0
  net_37: A11.1, A12.1
  net_38: A13.0, A12.2
  net_39: A4.0, A14.1
  net_40: A13.1, A14.2
  net_41: A15.0, A9.1
  net_42: A15.1, A14.0
  Port1: A52.0
  Port2: A4.1
  Port3: A5.1
  Port4: A3.0
setups:
  LinearFrequency: LinearFrequencyData(false, 0.1, false, "", false) SweepDefinition{Variable=F Data="LIN 3GHz 7GHz 0.005GHz"}
reports:
  S-Parameters: dB(S(Port1,Port1)), dB(S(Port2,Port1)), dB(S(Port3,Port1)), dB(S(Port4,Port1)) vs F on LinearFrequency : LinearFrequency; markers MX1 at x=5.2274742e+09, MY1 at y=-20
  S Parameter Plot 1: ang_deg(S(Port3,Port1)) vs F on LinearFrequency : LinearFrequency; markers MX1 at x=4.998513e+09

design Butler_Matrix (Circuit)
options: SParamCircuitDef IntegrationMethod=FFT
components:
  U1 = Hybrid_WB1()
  U2 = Hybrid_WB1()
  U3 = Hybrid_WB1()
  U417 = Crossover1()
  U4 = Crossover1()
  U5 = Hybrid_WB1()
  A424 = MS_TRL(W=1.76772mm P=7.2mm)
  A425 = MS_BENDC(W2=1.76772mm W1=1.76772mm)
  A1 = MS_BENDC(W2=1.76772mm W1=1.76772mm)
  A2 = MS_BENDC(W2=1.76772mm W1=1.76772mm)
  A3 = MS_BENDC(W2=1.76772mm W1=1.76772mm)
  A4 = MS_BENDC(W2=1.76772mm W1=1.76772mm)
  A5 = MS_BENDC(W2=1.76772mm W1=1.76772mm)
  A6 = MS_BENDC(W2=1.76772mm W1=1.76772mm)
  A7 = MS_BENDC(W2=1.76772mm W1=1.76772mm)
  A8 = MS_BENDC(W2=1.76772mm W1=1.76772mm)
  A9 = MS_BENDC(W2=1.76772mm W1=1.76772mm)
  A10 = MS_BENDC(W2=1.76772mm W1=1.76772mm)
  A11 = MS_BENDC(W2=1.76772mm W1=1.76772mm)
  A12 = MS_BENDC(W2=1.76772mm W1=1.76772mm)
  A13 = MS_TRL(W=1.76772mm P=8.95112mm)
  A14 = MS_BENDC(W2=1.76772mm W1=1.76772mm)
  A15 = MS_TRL(W=1.76772mm P=7.2mm)
  A16 = MS_TRL(W=1.76772mm P=7.2mm)
  A17 = MS_BENDC(W2=1.76772mm W1=1.76772mm)
  A18 = MS_TRL(W=1.76772mm P=7.2mm)
  A19 = MS_TRL(W=1.76772mm P=8.95112mm)
  A20 = MS_BENDC(W2=1.76772mm W1=1.76772mm)
  A21 = MS_TRL(W=1.76772mm P=8.95112mm)
  A22 = MS_TRL(W=1.76772mm P=8.95112mm)
  A23 = MS_TRL(W=1.76772mm P=21.43668mm)
  A24 = MS_TRL(W=1.76772mm P=21.43668mm)
  port Port1 pnum=1 rz=50ohm iz=0ohm noisetemp=16.85 noisetemporig=16.85cel
  port Port2 pnum=2 rz=50ohm iz=0ohm noisetemp=16.85 noisetemporig=16.85cel
  port Port3 pnum=3 rz=50ohm iz=0ohm noisetemp=16.85 noisetemporig=16.85cel
  port Port4 pnum=4 rz=50ohm iz=0ohm noisetemp=16.85 noisetemporig=16.85cel
  port Port5 pnum=5 rz=50ohm iz=0ohm noisetemp=16.85 noisetemporig=16.85cel
  port Port6 pnum=6 rz=50ohm iz=0ohm noisetemp=16.85 noisetemporig=16.85cel
  port Port7 pnum=7 rz=50ohm iz=0ohm noisetemp=16.85 noisetemporig=16.85cel
  port Port8 pnum=8 rz=50ohm iz=0ohm noisetemp=16.85 noisetemporig=16.85cel
nets:
  net_18: U417.3, A425.1
  net_19: U2.2, A1.0
  net_20: A1.1, U4.3
  net_21: U417.0, A2.0
  net_22: U4.0, A3.0
  net_23: U417.2, A4.0
  net_24: U4.2, A5.0
  net_25: U3.1, A5.1
  net_26: U417.1, A6.1
  net_27: U4.1, A7.1
  net_28: U5.1, A8.1
  net_29: U5.2, A425.0
  net_30: A4.1, U1.1
  net_31: U2.Port2, A2.1
  net_32: U3.0, A6.0
  net_33: U1.2, A9.0
  net_34: U2.0, A10.0
  net_35: U3.Port2, A11.1
  net_36: A424.0, A8.0
  net_37: A424.1, A12.0
  net_38: A12.1, A13.1
  net_39: A13.0, A14.0
  net_40: A10.1, A15.0
  net_41: A14.1, A15.1
  net_42: A9.1, A16.1
  net_43: A16.0, A17.1
  net_44: A18.1, A11.0
  net_45: A19.1, A17.0
  net_46: A18.0, A20.0
  net_47: A19.0, A20.1
  net_48: A3.1, A21.1
  net_49: A7.0, A22.1
  net_50: U2.1, A23.1
  net_51: U3.2, A24.1
  Port1: U5.0
  Port2: U5.Port2
  Port3: U1.0
  Port4: U1.Port2
  Port5: A23.0
  Port6: A21.0
  Port7: A22.0
  Port8: A24.0
setups:
  LinearFrequency: LinearFrequencyData(false, 0.1, false, "", false) SweepDefinition{Variable=F Data="LIN 3GHz 7GHz 0.005GHz"}
reports:
  S-Parameters: dB(S(Port1,Port1)), dB(S(Port2,Port1)), dB(S(Port3,Port1)), dB(S(Port4,Port1)) vs F on LinearFrequency : LinearFrequency; markers MX1 at x=5e+09, MY1 at y=-14
  Insertion Loss: dB(S(Port5,Port1)), dB(S(Port6,Port1)), dB(S(Port7,Port1)), dB(S(Port8,Port1)) vs F on LinearFrequency : LinearFrequency

design Hybrid_WB1 (Circuit)
options: SParamCircuitDef IntegrationMethod=FFT
components:
  A2 = MS_TRL(W=1.76772mm P=5mm)
  A1 = MS_TRL(W=1.76772mm P=5mm)
  A6 = MS_TEEC(W2=2.98223mm W1=1.76772mm W3=0.24287mm)
  A3 = MS_TEEC(W1=2.98223mm W2=1.76772mm W3=0.24287mm)
  A10 = MS_TRL(W=0.24287mm P=9.55345mm)
  A11 = MS_TRL(W=2.98223mm P=8.73787mm)
  A4 = MS_TRL(W=2.98223mm P=8.73787mm)
  A5 = MS_TEEC(W1=2.98223mm W2=2.98223mm W3=2.98223mm)
  A7 = MS_TEEC(W1=2.98223mm W2=2.98223mm W3=2.98223mm)
  A8 = MS_TRL(W=2.98223mm P=9.55345mm)
  A9 = MS_TRL(W=2.98223mm P=8.73787mm)
  A12 = MS_TRL(W=2.98223mm P=8.73787mm)
  A13 = MS_TEEC(W2=2.98223mm W1=1.76772mm W3=0.24287mm)
  A14 = MS_TEEC(W1=2.98223mm W2=1.76772mm W3=0.24287mm)
  A15 = MS_TRL(W=0.24287mm P=9.55345mm)
  A16 = MS_TRL(W=1.76772mm P=5mm)
  A17 = MS_TRL(W=1.76772mm P=5mm)
  port Port1 pnum=1 rz=50ohm iz=0ohm noisetemp=16.85 noisetemporig=16.85cel
  port Port2 pnum=2 rz=50ohm iz=0ohm noisetemp=16.85 noisetemporig=16.85cel
  port Port3 pnum=3 rz=50ohm iz=0ohm noisetemp=16.85 noisetemporig=16.85cel
  port Port4 pnum=4 rz=50ohm iz=0ohm noisetemp=16.85 noisetemporig=16.85cel
nets:
  net_1: A6.0, A2.1
  net_10: A5.2, A8.1
  net_11: A5.1, A9.0
  net_12: A12.0, A7.0
  net_13: A12.1, A13.1
  net_14: A14.0, A9.1
  net_15: A13.2, A15.0
  net_16: A14.2, A15.1
  net_17: A14.1, A16.0
  net_18: A17.0, A13.0
  net_2: A1.1, A3.1
  net_3: A6.2, A10.1
  net_4: A10.0, A3.2
  net_5: A6.1, A11.0
  net_6: A4.0, A3.0
  net_7: A5.0, A11.1
  net_8: A4.1, A7.1
  net_9: A7.2, A8.0
  Port1: A2.0
  Port2: A16.1
  Port3: A17.1
  Port4: A1.0
setups:
  LinearFrequency: LinearFrequencyData(false, 0.1, false, "", false) SweepDefinition{Variable=F Data="LIN 3GHz 7GHz 0.005GHz"}
output variables:
  phase_diff = abs((mod(abs(cang_rad(S(2,1))-cang_rad(S(3,1))),pi)-(pi/2))*180/pi)
  PortGainDiff = abs(dB(S(Port2,Port1))-dB(S(Port3,Port1)))

design Crossover1 (Circuit)
options: SParamCircuitDef IntegrationMethod=FFT
components:
  A52 = MS_TRL(W=1.76772mm P=5mm)
  A53 = MS_TEEC(W1=1.76772mm W2=1.76772mm W3=1.76772mm)
  A1 = MS_TRL(W=1.76772mm P=8.95112mm)
  A2 = MS_TEEC(W1=1.76772mm W2=1.76772mm W3=1.76772mm)
  A3 = MS_TRL(W=1.76772mm P=5mm)
  A6 = MS_TRL(W=1.76772mm P=8.95112mm)
  A7 = MS_TEEC(W1=1.76772mm W2=1.76772mm W3=1.76772mm)
  A8 = MS_TRL(W=1.76772mm P=8.95112mm)
  A9 = MS_TEEC(W1=1.76772mm W2=1.76772mm W3=1.76772mm)
  A10 = MS_TRL(W=1.76772mm P=8.95112mm)
  A5 = MS_TRL(W=1.76772mm P=5mm)
  A4 = MS_TRL(W=1.76772mm P=5mm)
  A11 = MS_TRL(W=1.76772mm P=8.95112mm)
  A12 = MS_TEEC(W1=1.76772mm W2=1.76772mm W3=1.76772mm)
  A13 = MS_TRL(W=1.76772mm P=8.95112mm)
  A14 = MS_TEEC(W1=1.76772mm W2=1.76772mm W3=1.76772mm)
  A15 = MS_TRL(W=1.76772mm P=8.95112mm)
  port Port1 pnum=1 rz=50ohm iz=0ohm noisetemp=16.85 noisetemporig=16.85cel
  port Port2 pnum=2 rz=50ohm iz=0ohm noisetemp=16.85 noisetemporig=16.85cel
  port Port3 pnum=3 rz=50ohm iz=0ohm noisetemp=16.85 noisetemporig=16.85cel
  port Port4 pnum=4 rz=50ohm iz=0ohm noisetemp=16.85 noisetemporig=16.85cel
nets:
  net_20: A53.0, A52.1
  net_21: A1.1, A53.2
  net_22: A2.2, A1.0
  net_23: A2.1, A3.1
  net_27: A2.0, A6.0
  net_29: A6.1, A7.1
  net_30: A7.2, A8.0
  net_32: A9.2, A8.1
  net_33: A10.0, A53.1
  net_34: A10.1, A9.0
  net_35: A7.0, A11.0
  net_36: A5.0, A12.0
  net_37: A11.1, A12.1
  net_38: A13.0, A12.2
  net_39: A4.0, A14.1
  net_40: A13.1, A14.2
  net_41: A15.0, A9.1
  net_42: A15.1, A14.0
  Port1: A52.0
  Port2: A4.1
  Port3: A5.1
  Port4: A3.0
setups:
  LinearFrequency: LinearFrequencyData(false, 0.1, false, "", false) SweepDefinition{Variable=F Data="LIN 3GHz 7GHz 0.005GHz"}
