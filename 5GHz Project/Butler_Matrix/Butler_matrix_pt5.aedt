# Ansys Electronics Desktop project, version 2018.2
project variables:
  $W_50 = 2.21849mm
  $L_50 = 8.92656mm
  $W_120 = 0.30894mm
  $W_70 = 1.19566mm
  $L_120 = 9.52516mm
materials:
  copper: permeability=0.999991 conductivity=58000000
  FR4_epoxy: permittivity=4.4 dielectric_loss_tangent=0.02
  Rogers RO4003 (tm): permittivity=3.55 dielectric_loss_tangent=0.0027

design Crossover (Circuit)
options: SParamCircuitDef IntegrationMethod=FFT
components:
  A52 = MS_TRL(W=1.76772mm P=5mm)
  A1 = MS_TRL(W=1.76772mm P=8.95112mm)
  A2 = MS_TEEC(W1=2.4943mm W2=1.76772mm W3=1.76772mm)
  A3 = MS_TRL(W=1.76772mm P=5mm)
  A6 = MS_TRL(W=2.4943mm P=8.81112mm)
  A7 = MS_TEEC(W1=1.15236mm W2=2.4943mm W3=1.15236mm)
  A8 = MS_TRL(W=1.15236mm P=8.95112mm)
  A9 = MS_TEEC(W1=2.4943mm W2=1.15236mm W3=1.15236mm)
  A10 = MS_TRL(W=2.4943mm P=8.81112mm)
  A5 = MS_TRL(W=2.4943mm P=8.81112mm)
  A4 = MS_TRL(W=2.4943mm P=8.81112mm)
  A11 = MS_TRL(W=1.15236mm P=9.11693mm)
  A12 = MS_TEEC(W1=2.4943mm W2=1.15236mm W3=1.15236mm)
  A13 = MS_TRL(W=1.15236mm P=8.95112mm)
  A14 = MS_TEEC(W1=1.15236mm W2=2.4943mm W3=1.15236mm)
  A15 = MS_TRL(W=1.15236mm P=9.11693mm)
  A16 = MS_TEEC(W1=2.4943mm W2=1.76772mm W3=1.76772mm)
  A17 = MS_TEEC(W1=1.76772mm W2=2.4943mm W3=1.76772mm)
  A18 = MS_TRL(W=1.76772mm P=8.95112mm)
  A19 = MS_TRL(W=1.76772mm P=5mm)
  A20 = MS_TRL(W=1.76772mm P=5mm)
  A21 = MS_TEEC(W1=1.76772mm W2=2.4943mm W3=1.76772mm)
  port Port1 pnum=1 rz=50ohm iz=0ohm noisetemp=16.85 noisetemporig=16.85cel
  port Port2 pnum=2 rz=50ohm iz=0ohm noisetemp=16.85 noisetemporig=16.85cel
  port Port3 pnum=3 rz=50ohm iz=0ohm noisetemp=16.85 noisetemporig=16.85cel
  port Port4 pnum=4 rz=50ohm iz=0ohm noisetemp=16.85 noisetemporig=16.85cel
nets:
  net_20: A52.1, A21.0
  net_21: A1.1, A21.2
  net_22: A2.2, A1.0
  net_23: A2.1, A3.1
  net_26: A4.1, A16.0
  net_27: A6.0, A2.0
  net_28: A17.1, A5.1
  net_29: A6.1, A7.1
  net_30: A8.0, A7.2
  net_31: A17.2, A18.0
  net_32: A8.1, A9.2
  net_33: A10.0, A21.1
  net_34: A10.1, A9.0
  net_35: A7.0, A11.0
  net_36: A5.0, A12.0
  net_37: A11.1, A12.1
  net_38: A12.2, A13.0
  net_39: A4.0, A14.1
  net_40: A14.2, A13.1
  net_41: A15.0, A9.1
  net_42: A15.1, A14.0
  net_43: A16.2, A18.1
  net_44: A19.0, A16.1
  net_45: A20.0, A17.0
  Port1: A52.0
  Port2: A19.1
  Port3: A20.1
  Port4: A3.0
setups:
  LinearFrequency: LinearFrequencyData(false, 0.1, false, "", false) SweepDefinition{Variable=F Data="LIN 3GHz 7GHz 0.005GHz"}
reports:
  S-Parameters: dB(S(Port1,Port1)), dB(S(Port2,Port1)), dB(S(Port3,Port1)), dB(S(Port4,Port1)) vs F on LinearFrequency : LinearFrequency; markers MX1 at x=5.0263158e+09, MY1 at y=-20
  S Parameter Plot 1: ang_deg(S(Port3,Port1)) vs F on LinearFrequency : LinearFrequency; markers MX1 at x=4.998513e+09

design Hybrid_WB (Circuit)
options: SParamCircuitDef IntegrationMethod=FFT
components:
  A2 = MS_TRL(W=1.76772mm P=5mm)
  A1 = MS_TRL(W=1.76772mm P=5mm)
  A10 = MS_TRL(W=0.24287mm P=9.55345mm)
  A11 = MS_TRL(W=1.76772mm P=8.95112mm)
  A4 = MS_TRL(W=1.76772mm P=8.95112mm)
  A8 = MS_TRL(W=0.95079mm P=9.55345mm)
  A9 = MS_TRL(W=1.76772mm P=8.95112mm)
  A12 = MS_TRL(W=1.76772mm P=8.95112mm)
  A15 = MS_TRL(W=0.24287mm P=9.55345mm)
  A16 = MS_TRL(W=1.76772mm P=5mm)
  A17 = MS_TRL(W=1.76772mm P=5mm)
  A53 = MS_TEEC(W1=1.76772mm W2=1.76772mm W3=0.24287mm)
  A54 = MS_TEEC(W1=1.76772mm W2=1.76772mm W3=0.95079mm)
  A55 = MS_TEEC(W1=1.76772mm W2=1.76772mm W3=0.24287mm)
  A56 = MS_TEEC(W2=1.76772mm W1=1.76772mm W3=0.24287mm)
  A3 = MS_TEEC(W1=1.76772mm W2=1.76772mm W3=0.95079mm)
  A5 = MS_TEEC(W1=1.76772mm W2=1.76772mm W3=0.24287mm)
  port Port1 pnum=1 rz=50ohm iz=0ohm noisetemp=16.85 noisetemporig=16.85cel
  port Port2 pnum=2 rz=50ohm iz=0ohm noisetemp=16.85 noisetemporig=16.85cel
  port Port3 pnum=3 rz=50ohm iz=0ohm noisetemp=16.85 noisetemporig=16.85cel
  port Port4 pnum=4 rz=50ohm iz=0ohm noisetemp=16.85 noisetemporig=16.85cel
nets:
  net_29: A2.1, A53.0
  net_30: A11.0, A53.1
  net_31: A10.1, A53.2
  net_32: A11.1, A54.0
  net_33: A9.0, A54.1
  net_34: A8.1, A54.2
  net_35: A9.1, A55.0
  net_36: A16.0, A55.1
  net_37: A15.1, A55.2
  net_38: A4.0, A56.0
  net_39: A56.1, A1.1
  net_40: A56.2, A10.0
  net_41: A3.0, A12.0
  net_42: A4.1, A3.1
  net_43: A8.0, A3.2
  net_44: A17.0, A5.0
  net_45: A12.1, A5.1
  net_46: A15.0, A5.2
  Port1: A2.0
  Port2: A16.1
  Port3: A17.1
  Port4: A1.0
setups:
  LinearFrequency: LinearFrequencyData(false, 0.1, false, "", false) SweepDefinition{Variable=F Data="LIN 3GHz 7GHz 0.005GHz"}
output variables:
  phase_diff = abs((mod(abs(cang_rad(S(2,1))-cang_rad(S(3,1))),pi)-(pi/2))*180/pi)
  PortGainDiff = abs(dB(S(Port2,Port1))-dB(S(Port3,Port1)))
reports:
  S-Parameters: dB(S(Port1,Port1)), dB(S(Port2,Port1)), dB(S(Port3,Port1)), dB(S(Port4,Port1)) vs F on LinearFrequency : LinearFrequency; markers MX1 at x=5.0014981e+09, MY1 at y=-14
  Port Gain Difference: PortGainDiff vs F on LinearFrequency : LinearFrequency; markers m1 at 5GHz, MY1 at y=0.5
  Phase Error: phase_diff vs F on LinearFrequency : LinearFrequency; markers m1 at 5GHz, MY1 at y=2

design Butler_Matrix (Circuit)
options: SParamCircuitDef IntegrationMethod=FFT
components:
  U476 = Hybrid_WB1()
  U477 = Hybrid_WB1()
  U478 = Hybrid_WB1()
  U479 = Hybrid_WB1()
  U481 = Crossover1()
  U482 = Crossover1()
  A483 = MS_BENDC(W2=1.76772mm W1=1.76772mm)
  A1 = MS_BENDC(W2=1.76772mm W1=1.76772mm)
  A2 = MS_BENDC(W2=1.76772mm W1=1.76772mm)
  A3 = MS_BENDC(W2=1.76772mm W1=1.76772mm)
  A4 = MS_BENDC(W2=1.76772mm W1=1.76772mm)
  A5 = MS_BENDC(W2=1.76772mm W1=1.76772mm)
  A6 = MS_BENDC(W2=1.76772mm W1=1.76772mm)
  A7 = MS_BENDC(W2=1.76772mm W1=1.76772mm)
  A8 = MS_BENDC(W2=1.76772mm W1=1.76772mm)
  A9 = MS_BENDC(W2=1.76772mm W1=1.76772mm)
  A511 = MS_TRL(W=1.76772mm P=7.2mm)
  A10 = MS_TRL(W=1.76772mm P=7.2mm)
  A11 = MS_TRL(W=1.76772mm P=7.2mm)
  A12 = MS_TRL(W=1.76772mm P=7.2mm)
  A13 = MS_BENDC(W2=1.76772mm W1=1.76772mm)
  A14 = MS_BENDC(W2=1.76772mm W1=1.76772mm)
  A529 = MS_TRL(W=1.76772mm P=9.6777mm)
  A15 = MS_BENDC(W2=1.76772mm W1=1.76772mm)
  A16 = MS_BENDC(W2=1.76772mm W1=1.76772mm)
  A17 = MS_TRL(W=1.76772mm P=9.6777mm)
  A539 = MS_TRL(W=1.76772mm P=8.95112mm)
  A18 = MS_TRL(W=1.76772mm P=8.95112mm)
  A19 = MS_TRL(W=1.76772mm P=22.16376mm)
  A20 = MS_TRL(W=1.76772mm P=22.16376mm)
  A21 = MS_BENDC(W2=1.76772mm W1=1.76772mm)
  A22 = MS_BENDC(W2=1.76772mm W1=1.76772mm)
  port Port1 pnum=1 rz=50ohm iz=0ohm noisetemp=16.85 noisetemporig=16.85cel
  port Port2 pnum=2 rz=50ohm iz=0ohm noisetemp=16.85 noisetemporig=16.85cel
  port Port3 pnum=3 rz=50ohm iz=0ohm noisetemp=16.85 noisetemporig=16.85cel
  port Port4 pnum=4 rz=50ohm iz=0ohm noisetemp=16.85 noisetemporig=16.85cel
  port Port5 pnum=5 rz=50ohm iz=0ohm noisetemp=16.85 noisetemporig=16.85cel
  port Port6 pnum=6 rz=50ohm iz=0ohm noisetemp=16.85 noisetemporig=16.85cel
  port Port7 pnum=7 rz=50ohm iz=0ohm noisetemp=16.85 noisetemporig=16.85cel
  port Port8 pnum=8 rz=50ohm iz=0ohm noisetemp=16.85 noisetemporig=16.85cel
nets:
  net_51: U481.3, A483.1
  net_52: U476.2, A483.0
  net_53: A1.1, U482.3
  net_54: U477.2, A1.0
  net_55: U481.0, A2.0
  net_56: U481.2, A3.0
  net_57: U481.1, A4.1
  net_58: A4.0, U479.0
  net_59: U478.1, A3.1
  net_60: A2.1, U477.Port2
  net_61: A5.0, U482.2
  net_62: A5.1, U479.1
  net_63: U476.1, A6.1
  net_64: U477.0, A7.0
  net_65: U478.2, A8.0
  net_66: A9.1, U479.Port2
  net_67: A511.0, A8.1
  net_68: A10.1, A6.0
  net_69: A11.1, A7.1
  net_70: A9.0, A12.0
  net_71: A13.1, A511.1
  net_72: A12.1, A14.0
  net_73: A13.0, A529.0
  net_74: A529.1, A14.1
  net_75: A15.0, A10.0
  net_76: A16.1, A11.0
  net_77: A15.1, A17.0
  net_78: A16.0, A17.1
  net_81: U477.1, A19.0
  net_82: A20.0, U479.2
  net_83: A21.0, U482.0
  net_84: A22.1, U482.1
  net_85: A18.0, A22.0
  net_86: A539.0, A21.1
  Port1: U476.0
  Port2: U476.Port2
  Port3: U478.0
  Port4: U478.Port2
  Port5: A19.1
  Port6: A539.1
  Port7: A18.1
  Port8: A20.1
setups:
  LinearFrequency: LinearFrequencyData(false, 0.1, false, "", false) SweepDefinition{Variable=F Data="LIN 3GHz 7GHz 0.005GHz"}
reports:
  S-Parameters: dB(S(Port1,Port1)), dB(S(Port2,Port1)), dB(S(Port3,Port1)), dB(S(Port4,Port1)) vs F on LinearFrequency : LinearFrequency; markers MX1 at x=5.005997e+09, MY1 at y=-14
  Insertion Loss: dB(S(Port5,Port1)), dB(S(Port6,Port1)), dB(S(Port7,Port1)), dB(S(Port8,Port1)) vs F on LinearFrequency : LinearFrequency; markers MX1 at x=5.005997e+09

design Hybrid_WB1 (Circuit)
options: SParamCircuitDef IntegrationMethod=FFT
components:
  A2 = MS_TRL(W=1.76772mm P=5mm)
  A1 = MS_TRL(W=1.76772mm P=5mm)
  A10 = MS_TRL(W=0.24287mm P=9.55345mm)
  A11 = MS_TRL(W=1.76772mm P=8.95112mm)
  A4 = MS_TRL(W=1.76772mm P=8.95112mm)
  A8 = MS_TRL(W=0.95079mm P=9.55345mm)
  A9 = MS_TRL(W=1.76772mm P=8.95112mm)
  A12 = MS_TRL(W=1.76772mm P=8.95112mm)
  A15 = MS_TRL(W=0.24287mm P=9.55345mm)
  A16 = MS_TRL(W=1.76772mm P=5mm)
  A17 = MS_TRL(W=1.76772mm P=5mm)
  A53 = MS_TEEC(W1=1.76772mm W2=1.76772mm W3=0.24287mm)
  A54 = MS_TEEC(W1=1.76772mm W2=1.76772mm W3=0.95079mm)
  A55 = MS_TEEC(W1=1.76772mm W2=1.76772mm W3=0.24287mm)
  A56 = MS_TEEC(W2=1.76772mm W1=1.76772mm W3=0.24287mm)
  A3 = MS_TEEC(W1=1.76772mm W2=1.76772mm W3=0.95079mm)
  A5 = MS_TEEC(W1=1.76772mm W2=1.76772mm W3=0.24287mm)
  port Port1 pnum=1 rz=50ohm iz=0ohm noisetemp=16.85 noisetemporig=16.85cel
  port Port2 pnum=2 rz=50ohm iz=0ohm noisetemp=16.85 noisetemporig=16.85cel
  port Port3 pnum=3 rz=50ohm iz=0ohm noisetemp=16.85 noisetemporig=16.85cel
  port Port4 pnum=4 rz=50ohm iz=0ohm noisetemp=16.85 noisetemporig=16.85cel
nets:
  net_29: A53.0, A2.1
  net_30: A11.0, A53.1
  net_31: A10.1, A53.2
  net_32: A11.1, A54.0
  net_33: A9.0, A54.1
  net_34: A8.1, A54.2
  net_35: A9.1, A55.0
  net_36: A55.1, A16.0
  net_37: A55.2, A15.1
  net_38: A4.0, A56.0
  net_39: A1.1, A56.1
  net_40: A10.0, A56.2
  net_41: A12.0, A3.0
  net_42: A4.1, A3.1
  net_43: A8.0, A3.2
  net_44: A17.0, A5.0
  net_45: A12.1, A5.1
  net_46: A15.0, A5.2
  Port1: A2.0
  Port2: A16.1
  Port3: A17.1
  Port4: A1.0
setups:
  LinearFrequency: LinearFrequencyData(false, 0.1, false, "", false) SweepDefinition{Variable=F Data="LIN 3GHz 7GHz 0.005GHz"}
output variables:
  phase_diff = abs((mod(abs(cang_rad(S(2,1))-cang_rad(S(3,1))),pi)-(pi/2))*180/pi)
  PortGainDiff = abs(dB(S(Port2,Port1))-dB(S(Port3,Port1)))

design Crossover1 (Circuit)
options: SParamCircuitDef IntegrationMethod=FFT
components:
  A52 = MS_TRL(W=1.76772mm P=5mm)
  A1 = MS_TRL(W=1.76772mm P=8.95112mm)
  A2 = MS_TEEC(W1=2.4943mm W2=1.76772mm W3=1.76772mm)
  A3 = MS_TRL(W=1.76772mm P=5mm)
  A6 = MS_TRL(W=2.4943mm P=8.81112mm)
  A7 = MS_TEEC(W1=1.15236mm W2=2.4943mm W3=1.15236mm)
  A8 = MS_TRL(W=1.15236mm P=8.95112mm)
  A9 = MS_TEEC(W1=2.4943mm W2=1.15236mm W3=1.15236mm)
  A10 = MS_TRL(W=2.4943mm P=8.81112mm)
  A5 = MS_TRL(W=2.4943mm P=8.81112mm)
  A4 = MS_TRL(W=2.4943mm P=8.81112mm)
  A11 = MS_TRL(W=1.15236mm P=9.11693mm)
  A12 = MS_TEEC(W1=2.4943mm W2=1.15236mm W3=1.15236mm)
  A13 = MS_TRL(W=1.15236mm P=8.95112mm)
  A14 = MS_TEEC(W1=1.15236mm W2=2.4943mm W3=1.15236mm)
  A15 = MS_TRL(W=1.15236mm P=9.11693mm)
  A16 = MS_TEEC(W1=2.4943mm W2=1.76772mm W3=1.76772mm)
  A17 = MS_TEEC(W1=1.76772mm W2=2.4943mm W3=1.76772mm)
  A18 = MS_TRL(W=1.76772mm P=8.95112mm)
  A19 = MS_TRL(W=1.76772mm P=5mm)
  A20 = MS_TRL(W=1.76772mm P=5mm)
  A21 = MS_TEEC(W1=1.76772mm W2=2.4943mm W3=1.76772mm)
  port Port1 pnum=1 rz=50ohm iz=0ohm noisetemp=16.85 noisetemporig=16.85cel
  port Port2 pnum=2 rz=50ohm iz=0ohm noisetemp=16.85 noisetemporig=16.85cel
  port Port3 pnum=3 rz=50ohm iz=0ohm noisetemp=16.85 noisetemporig=16.85cel
  port Port4 pnum=4 rz=50ohm iz=0ohm noisetemp=16.85 noisetemporig=16.85cel
nets:
  net_20: A52.1, A21.0
  net_21: A1.1, A21.2
  net_22: A1.0, A2.2
  net_23: A2.1, A3.1
  net_26: A4.1, A16.0
  net_27: A6.0, A2.0
  net_28: A5.1, A17.1
  net_29: A7.1, A6.1
  net_30: A7.2, A8.0
  net_31: A18.0, A17.2
  net_32: A9.2, A8.1
  net_33: A10.0, A21.1
  net_34: A10.1, A9.0
  net_35: A7.0, A11.0
  net_36: A5.0, A12.0
  net_37: A12.1, A11.1
  net_38: A12.2, A13.0
  net_39: A14.1, A4.0
  net_40: A14.2, A13.1
  net_41: A15.0, A9.1
  net_42: A15.1, A14.0
  net_43: A18.1, A16.2
  net_44: A19.0, A16.1
  net_45: A17.0, A20.0
  Port1: A52.0
  Port2: A19.1
  Port3: A20.1
  Port4: A3.0
setups:
  LinearFrequency: LinearFrequencyData(false, 0.1, false, "", false) SweepDefinition{Variable=F Data="LIN 3GHz 7GHz 0.005GHz"}
