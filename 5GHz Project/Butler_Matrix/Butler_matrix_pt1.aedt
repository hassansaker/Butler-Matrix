# Ansys Electronics Desktop project, version 2018.2
materials:
  copper: permeability=0.999991 conductivity=58000000
  FR4_epoxy: permittivity=4.4 dielectric_loss_tangent=0.02
  Rogers RO4003 (tm): permittivity=3.55 dielectric_loss_tangent=0.0027

design Hybrid_90 (Circuit)
options: SParamCircuitDef IntegrationMethod=FFT
components:
  A1 = MS_TRL(W=1.76772mm P=8.95112mm)
  A2 = MS_TEEC(W1=1.76772mm W3=1.76772mm W2=2.98223mm)
  A3 = MS_TRL(W=1.76772mm P=8.95112mm)
  A6 = MS_TRL(W=2.98223mm P=8.73787mm)
  A4 = MS_TRL(W=2.98223mm P=8.73787mm)
  A5 = MS_TEEC(W1=2.98223mm W3=1.76772mm W2=1.76772mm)
  A7 = MS_TEEC(W1=2.98223mm W3=1.76772mm W2=1.76772mm)
  A8 = MS_TEEC(W1=1.76772mm W3=1.76772mm W2=2.98223mm)
  A9 = MS_TRL(W=1.76772mm P=8.95112mm)
  A10 = MS_TRL(W=1.76772mm P=8.95112mm)
  A11 = MS_TRL(W=1.76772mm P=8.95112mm)
  A12 = MS_TRL(W=1.76772mm P=8.95112mm)
  port Port1 pnum=1 rz=50ohm iz=0ohm noisetemp=16.85 noisetemporig=16.85cel
  port Port2 pnum=2 rz=50ohm iz=0ohm noisetemp=16.85 noisetemporig=16.85cel
  port Port3 pnum=3 rz=50ohm iz=0ohm noisetemp=16.85 noisetemporig=16.85cel
  port Port4 pnum=4 rz=50ohm iz=0ohm noisetemp=16.85 noisetemporig=16.85cel
nets:
  net_1: A1.1, A2.0
  net_10: A5.1, A10.1
  net_11: A11.0, A7.1
  net_12: A12.0, A8.0
  net_2: A3.1, A2.2
  net_3: A2.1, A6.0
  net_4: A3.0, A5.2
  net_5: A4.0, A5.0
  net_6: A7.0, A6.1
  net_7: A4.1, A8.1
  net_8: A8.2, A9.0
  net_9: A7.2, A9.1
  Port1: A1.0
  Port2: A11.1
  Port3: A12.1
  Port4: A10.0
setups:
  LinearFrequency: LinearFrequencyData(false, 0.1, false, "", false) SweepDefinition{Variable=F Data="LIN 3GHz 7GHz 0.005GHz"}
output variables:
  Phase_Defference = abs(ang_deg(S(Port2,Port1))-ang_deg(S(Port3,Port1))-pi/2)
reports:
  S-Parameters: dB(S(Port1,Port1)), dB(S(Port2,Port1)), dB(S(Port3,Port1)), dB(S(Port4,Port1)) vs F on LinearFrequency : LinearFrequency; markers MX1 at x=4.9409061e+09, MY1 at y=-14
  Phase_Error: Phase_Defference vs F on LinearFrequency : LinearFrequency

design Crossover (Circuit)
options: SParamCircuitDef IntegrationMethod=FFT
components:
  A52 = MS_TRL(W=1.76772mm P=5mm)
  A53 = MS_TEEC(W1=1.76772mm W2=1.76772mm W3=1.76772mm)
  A1 = MS_TRL(W=1.76772mm P=8.95112mm)
  A2 = MS_TEEC(W1=1.76772mm W2=1.76772mm W3=1.76772mm)
  A3 = MS_TRL(W=1.76772mm P=5mm)
  A6 = MS_TRL(W=1.76772mm P=8.95112mm)
  A7 = MS_TEEC(W1=1.76772mm W2=1.76772mm W3=1.76772mm)
  A8 = MS_TRL(W=1.76772mm P=8.95112mm)
  A9 = MS_TEEC(W1=1.76772mm W2=1.76772mm W3=1.76772mm)
  A10 = MS_TRL(W=1.76772mm P=8.95112mm)
  A5 = MS_TRL(W=1.76772mm P=5mm)
  A4 = MS_TRL(W=1.76772mm P=5mm)
  A11 = MS_TRL(W=1.76772mm P=8.95112mm)
  A12 = MS_TEEC(W1=1.76772mm W2=1.76772mm W3=1.76772mm)
  A13 = MS_TRL(W=1.76772mm P=8.95112mm)
  A14 = MS_TEEC(W1=1.76772mm W2=1.76772mm W3=1.76772mm)
  A15 = MS_TRL(W=1.76772mm P=8.95112mm)
  port Port1 pnum=1 rz=50ohm iz=0ohm noisetemp=16.85 noisetemporig=16.85cel
  port Port2 pnum=2 rz=50ohm iz=0ohm noisetemp=16.85 noisetemporig=16.85cel
  port Port3 pnum=3 rz=50ohm iz=0ohm noisetemp=16.85 noisetemporig=16.85cel
  port Port4 pnum=4 rz=50ohm iz=0ohm noisetemp=16.85 noisetemporig=16.85cel
nets:
  net_20: A52.1, A53.0
  net_21: A1.1, A53.2
  net_22: A2.2, A1.0
  net_23: A2.1, A3.1
  net_27: A2.0, A6.0
  net_29: A6.1, A7.1
  net_30: A7.2, A8.0
  net_32: A9.2, A8.1
  net_33: A10.0, A53.1
  net_34: A9.0, A10.1
  net_35: A7.0, A11.0
  net_36: A5.0, A12.0
  net_37: A12.1, A11.1
  net_38: A13.0, A12.2
  net_39: A4.0, A14.1
  net_40: A13.1, A14.2
  net_41: A15.0, A9.1
  net_42: A15.1, A14.0
  Port1: A52.0
  Port2: A4.1
  Port3: A5.1
  Port4: A3.0
setups:
  LinearFrequency: LinearFrequencyData(false, 0.1, false, "", false) SweepDefinition{Variable=F Data="LIN 3GHz 7GHz 0.005GHz"}
reports:
  S-Parameters: dB(S(Port1,Port1)), dB(S(Port2,Port1)), dB(S(Port3,Port1)), dB(S(Port4,Port1)) vs F on LinearFrequency : LinearFrequency; markers MX1 at x=5.2274742e+09, MY1 at y=-20
  S Parameter Plot 1: ang_deg(S(Port3,Port1)) vs F on LinearFrequency : LinearFrequency; markers MX1 at x=4.998513e+09

design Butler_Matrix (Circuit)
options: SParamCircuitDef IntegrationMethod=FFT
components:
  A330 = MS_BENDC(W2=1.76772mm W1=1.76772mm)
  A1 = MS_BENDC(W2=1.76772mm W1=1.76772mm)
  A2 = MS_BENDC(W2=1.76772mm W1=1.76772mm)
  A3 = MS_BENDC(W2=1.76772mm W1=1.76772mm)
  A4 = MS_BENDC(W2=1.76772mm W1=1.76772mm)
  A5 = MS_BENDC(W2=1.76772mm W1=1.76772mm)
  A6 = MS_BENDC(W2=1.76772mm W1=1.76772mm)
  A349 = MS_TRL(W=1.76772mm P=7.2mm)
  A7 = MS_BENDC(W2=1.76772mm W1=1.76772mm)
  A8 = MS_TRL(W=1.76772mm P=8.95112mm)
  A9 = MS_BENDC(W2=1.76772mm W1=1.76772mm)
  A10 = MS_TRL(W=1.76772mm P=7.2mm)
  A11 = MS_BENDC(W2=1.76772mm W1=1.76772mm)
  A12 = MS_BENDC(W2=1.76772mm W1=1.76772mm)
  A13 = MS_TRL(W=1.76772mm P=7.2mm)
  A14 = MS_BENDC(W2=1.76772mm W1=1.76772mm)
  A15 = MS_TRL(W=1.76772mm P=8.95112mm)
  A16 = MS_BENDC(W2=1.76772mm W1=1.76772mm)
  A17 = MS_TRL(W=1.76772mm P=7.2mm)
  A18 = MS_BENDC(W2=1.76772mm W1=1.76772mm)
  A19 = MS_BENDC(W2=1.76772mm W1=1.76772mm)
  A20 = MS_BENDC(W2=1.76772mm W1=1.76772mm)
  A21 = MS_TRL(W=1.76772mm P=22.16376mm)
  A22 = MS_TRL(W=1.76772mm P=22.16376mm)
  A23 = MS_TRL(W=1.76772mm P=8.95112mm)
  A24 = MS_TRL(W=1.76772mm P=8.95112mm)
  U412 = Hybrid_91()
  U1 = Hybrid_91()
  U2 = Hybrid_91()
  U3 = Hybrid_91()
  U419 = Crossover1()
  U4 = Crossover1()
  port Port1 pnum=1 rz=50ohm iz=0ohm noisetemp=16.85 noisetemporig=16.85cel
  port Port2 pnum=2 rz=50ohm iz=0ohm noisetemp=16.85 noisetemporig=16.85cel
  port Port3 pnum=3 rz=50ohm iz=0ohm noisetemp=16.85 noisetemporig=16.85cel
  port Port4 pnum=4 rz=50ohm iz=0ohm noisetemp=16.85 noisetemporig=16.85cel
  port Port5 pnum=5 rz=50ohm iz=0ohm noisetemp=16.85 noisetemporig=16.85cel
  port Port6 pnum=6 rz=50ohm iz=0ohm noisetemp=16.85 noisetemporig=16.85cel
  port Port7 pnum=7 rz=50ohm iz=0ohm noisetemp=16.85 noisetemporig=16.85cel
  port Port8 pnum=8 rz=50ohm iz=0ohm noisetemp=16.85 noisetemporig=16.85cel
nets:
  net_43: A6.1, U412.Port1
  net_44: U1.0, A11.0
  net_45: U1.Port1, A21.1
  net_46: U2.Port2, A12.0
  net_47: A19.1, A23.1
  net_48: A24.1, A20.0
  net_49: U3.Port3, A18.1
  net_50: U3.Port2, A22.1
  net_51: A3.0, U419.0
  net_52: A2.1, U419.3
  net_53: A330.1, U419.1
  net_54: A1.0, U419.2
  net_55: A1.1, U2.Port1
  net_56: A330.0, U3.0
  net_57: U4.0, A19.0
  net_58: A2.0, U412.Port2
  net_59: A4.1, U4.3
  net_60: A3.1, U1.Port3
  net_61: A4.0, U1.Port2
  net_62: U4.1, A20.1
  net_63: A5.0, U4.2
  net_64: A5.1, U3.Port1
  net_66: A6.0, A349.0
  net_67: A7.0, A349.1
  net_68: A7.1, A8.1
  net_69: A8.0, A9.0
  net_70: A9.1, A10.1
  net_71: A10.0, A11.1
  net_74: A13.1, A12.1
  net_75: A13.0, A14.1
  net_76: A14.0, A15.1
  net_77: A15.0, A16.1
  net_78: A17.0, A16.0
  net_79: A17.1, A18.0
  Port1: U412.0
  Port2: U412.Port3
  Port3: U2.0
  Port4: U2.Port3
  Port5: A21.0
  Port6: A23.0
  Port7: A24.0
  Port8: A22.0
setups:
  LinearFrequency: LinearFrequencyData(false, 0.1, false, "", false) SweepDefinition{Variable=F Data="LIN 3GHz 7GHz 0.005GHz"}
reports:
  S-Parameters: dB(S(Port1,Port1)), dB(S(Port2,Port1)), dB(S(Port3,Port1)), dB(S(Port4,Port1)) vs F on LinearFrequency : LinearFrequency; markers MX1 at x=5e+09, MY1 at y=-14
  Insertion Loss: dB(S(Port5,Port1)), dB(S(Port6,Port1)), dB(S(Port7,Port1)), dB(S(Port8,Port1)) vs F on LinearFrequency : LinearFrequency; markers MX1 at x=5.005997e+09

design Hybrid_91 (Circuit)
options: SParamCircuitDef IntegrationMethod=FFT
components:
  A1 = MS_TRL(W=1.76772mm P=8.95112mm)
  A2 = MS_TEEC(W1=1.76772mm W3=1.76772mm W2=2.98223mm)
  A3 = MS_TRL(W=1.76772mm P=8.95112mm)
  A6 = MS_TRL(W=2.98223mm P=8.73787mm)
  A4 = MS_TRL(W=2.98223mm P=8.73787mm)
  A5 = MS_TEEC(W1=2.98223mm W3=1.76772mm W2=1.76772mm)
  A7 = MS_TEEC(W1=2.98223mm W3=1.76772mm W2=1.76772mm)
  A8 = MS_TEEC(W1=1.76772mm W3=1.76772mm W2=2.98223mm)
  A9 = MS_TRL(W=1.76772mm P=8.95112mm)
  A10 = MS_TRL(W=1.76772mm P=8.95112mm)
  A11 = MS_TRL(W=1.76772mm P=8.95112mm)
  A12 = MS_TRL(W=1.76772mm P=8.95112mm)
  port Port1 pnum=1 rz=50ohm iz=0ohm noisetemp=16.85 noisetemporig=16.85cel
  port Port2 pnum=2 rz=50ohm iz=0ohm noisetemp=16.85 noisetemporig=16.85cel
  port Port3 pnum=3 rz=50ohm iz=0ohm noisetemp=16.85 noisetemporig=16.85cel
  port Port4 pnum=4 rz=50ohm iz=0ohm noisetemp=16.85 noisetemporig=16.85cel
nets:
  net_1: A1.1, A2.0
  net_10: A10.1, A5.1
  net_11: A7.1, A11.0
  net_12: A12.0, A8.0
  net_2: A3.1, A2.2
  net_3: A2.1, A6.0
  net_4: A3.0, A5.2
  net_5: A4.0, A5.0
  net_6: A7.0, A6.1
  net_7: A4.1, A8.1
  net_8: A9.0, A8.2
  net_9: A7.2, A9.1
  Port1: A1.0
  Port2: A11.1
  Port3: A12.1
  Port4: A10.0
setups:
  LinearFrequency: LinearFrequencyData(false, 0.1, false, "", false) SweepDefinition{Variable=F Data="LIN 3GHz 7GHz 0.005GHz"}
output variables:
  Phase_Defference = abs(ang_deg(S(Port2,Port1))-ang_deg(S(Port3,Port1))-pi/2)

design Crossover1 (Circuit)
options: SParamCircuitDef IntegrationMethod=FFT
components:
  A52 = MS_TRL(W=1.76772mm P=5mm)
  A53 = MS_TEEC(W1=1.76772mm W2=1.76772mm W3=1.76772mm)
  A1 = MS_TRL(W=1.76772mm P=8.95112mm)
  A2 = MS_TEEC(W1=1.76772mm W2=1.76772mm W3=1.76772mm)
  A3 = MS_TRL(W=1.76772mm P=5mm)
  A6 = MS_TRL(W=1.76772mm P=8.95112mm)
  A7 = MS_TEEC(W1=1.76772mm W2=1.76772mm W3=1.76772mm)
  A8 = MS_TRL(W=1.76772mm P=8.95112mm)
  A9 = MS_TEEC(W1=1.76772mm W2=1.76772mm W3=1.76772mm)
  A10 = MS_TRL(W=1.76772mm P=8.95112mm)
  A5 = MS_TRL(W=1.76772mm P=5mm)
  A4 = MS_TRL(W=1.76772mm P=5mm)
  A11 = MS_TRL(W=1.76772mm P=8.95112mm)
  A12 = MS_TEEC(W1=1.76772mm W2=1.76772mm W3=1.76772mm)
  A13 = MS_TRL(W=1.76772mm P=8.95112mm)
  A14 = MS_TEEC(W1=1.76772mm W2=1.76772mm W3=1.76772mm)
  A15 = MS_TRL(W=1.76772mm P=8.95112mm)
  port Port1 pnum=1 rz=50ohm iz=0ohm noisetemp=16.85 noisetemporig=16.85cel
  port Port2 pnum=2 rz=50ohm iz=0ohm noisetemp=16.85 noisetemporig=16.85cel
  port Port3 pnum=3 rz=50ohm iz=0ohm noisetemp=16.85 noisetemporig=16.85cel
  port Port4 pnum=4 rz=50ohm iz=0ohm noisetemp=16.85 noisetemporig=16.85cel
nets:
  net_20: A53.0, A52.1
  net_21: A53.2, A1.1
  net_22: A2.2, A1.0
  net_23: A2.1, A3.1
  net_27: A2.0, A6.0
  net_29: A6.1, A7.1
  net_30: A8.0, A7.2
  net_32: A8.1, A9.2
  net_33: A10.0, A53.1
  net_34: A10.1, A9.0
  net_35: A7.0, A11.0
  net_36: A12.0, A5.0
  net_37: A12.1, A11.1
  net_38: A12.2, A13.0
  net_39: A4.0, A14.1
  net_40: A13.1, A14.2
  net_41: A15.0, A9.1
  net_42: A15.1, A14.0
  Port1: A52.0
  Port2: A4.1
  Port3: A5.1
  Port4: A3.0
setups:
  LinearFrequency: LinearFrequencyData(false, 0.1, false, "", false) SweepDefinition{Variable=F Data="LIN 3GHz 7GHz 0.005GHz"}
