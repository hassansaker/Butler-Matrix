# Ansys Electronics Desktop project, version 2018.2
project variables:
  $W_50 = 2.21849mm
  $L_50 = 8.92656mm
  $W_120 = 0.30894mm
  $W_70 = 1.19566mm
  $L_120 = 9.52516mm
materials:
  copper: permeability=0.999991 conductivity=58000000
  FR4_epoxy: permittivity=4.4 dielectric_loss_tangent=0.02
  Rogers RO4003 (tm): permittivity=3.55 dielectric_loss_tangent=0.0027
  vacuum: permittivity=1

design Butler_Matrix_4x4 (HFSS, DrivenModal, model units mm)
variables:
  H = 0.8mm
  W_50 = 2.3mm
  Hybrid_L_35 = 7.82mm
  Hybrid_L_50 = 7.05mm
  Hybrid_L = 2*Hybrid_L_feed+Hybrid_W_120+2*Hybrid_L_50
  Hybrid_W = 25mm
  Hybrid_W_50 = 1.7645mm
  Hybrid_W_35 = 2.985mm
  Hybrid_L_feed = 5mm
  Cross_L_50 = Cross_L_64
  Cross_W_50 = 1.76772mm
  Cross_L_feed = 5mm
  Cross_L = 2*Cross_L_feed+2*Cross_L_40+Cross_L_64+Cross_W_50
  Cross_W = 25mm
  Phase_c = 6.920022mm
  Phase_W = 40mm
  Phase_W_50 = 1.7645mm
  Phase_a = 1.5mm
  Phase_b = 9.3mm
  L_feed6 = L_feed5
  L_feed7 = L_feed5
  L_feed5 = 7.1mm
  L = 2*Hybrid_L+2*Cross_L_50+2*Cross_W_50+2*Cross_W_40+L_feed5
  L_feed8 = L_feed5
  W = Cross_L+6*Hybrid_W_50+2*Hybrid_L_50+2*Phase_b
  exten_b = 4mm
  exten_W_50 = 1.7645mm
  exten_a = 6.724511mm
  exten_c = 8.5mm
  exten_W = 30mm
  exten_L = 2*exten_a+2*exten_W_50+exten_c
  Phase_L = 2*Phase_a+2*Phase_W_50+Phase_c
  L_feed = 5mm
  L_50 = 9.2mm
  exten_pad = 6mm
  Cross_L_64 = 9.348402mm
  Cross_W_64 = 1.1734mm
  Cross_L_40 = 7.9149mm
  Cross_W_40 = 2.3329mm
  Hybrid_W_120 = 0.2532mm
  Hybrid_L_120 = 8.0138mm
  Hyrid_L_feed = 5mm
  Hybrid_W_70 = 0.95079mm
geometry:
  Box1 [Rogers RO4003 (tm)] = box(corner=(-25mm, 0mm, 0mm), size=(W+42.292mm, L, H))
  Ground = object_from(Box1.face(-z))
  Port2 = rectangle(corner=(Hybrid_W/2+Hybrid_L_120/2, 0mm, H), z_size=-H, x_size=Hybrid_W_50)
  Port1 = rectangle(corner=(Hybrid_W/2-Hybrid_L_120/2, 0mm, H), z_size=-H, x_size=-Hybrid_W_50)
  Port3 = rectangle(corner=(Cross_L+Hybrid_W/2+Hybrid_L_120/2+Hybrid_W_50, 0mm, H), z_size=-H, x_size=Hybrid_W_50)
  Port4 = rectangle(corner=(Cross_L+Hybrid_W/2+1.5*Hybrid_L_120+2*Hybrid_W_50, 0mm, H), z_size=-H, x_size=Hybrid_W_50)
  Port5 = rectangle(corner=(Hybrid_W/2-Hybrid_L_120/2-2*exten_W_50-2*exten_c, L, H), z_size=-H, x_size=-Hybrid_W_50)
  Port6 = rectangle(corner=(Hybrid_W/2+Hybrid_L_120/2, L, H), z_size=-H, x_size=Cross_W_50)
  Port7 = rectangle(corner=(Cross_L+Hybrid_W/2+Hybrid_L_120/2+Hybrid_W_50, L, H), z_size=-H, x_size=Cross_W_50)
  Port8 = rectangle(corner=(Cross_L+Hybrid_W/2+1.5*Hybrid_L_120+4*Hybrid_W_50+2*exten_c, L, H), z_size=-H, x_size=Hybrid_W_50)
  Box2 [vacuum] = box(corner=(-35mm, -10mm, -10mm), size=(W+70mm-2*3.854mm, 20mm+L, 20mm))
  Bend_1 = polyline(z=H, xy: (Hybrid_W/2+Hybrid_L_120/2+Hybrid_W_50, Hybrid_L) (Hybrid_W/2+Hybrid_L_120/2+Hybrid_W_50, Hybrid_L+Cross_W_50) (Hybrid_W/2+Hybrid_L_120/2, Hybrid_L) (Hybrid_W/2+Hybrid_L_120/2+Hybrid_W_50, Hybrid_L), closed, covered)
  Bend_2 = polyline(z=H, xy: (Cross_L+Hybrid_W/2+Hybrid_L_120/2+Hybrid_W_50, Hybrid_L) (Cross_L+Hybrid_W/2+Hybrid_L_120/2+2*Hybrid_W_50, Hybrid_L) (Cross_L+Hybrid_W/2+Hybrid_L_120/2+Hybrid_W_50, Hybrid_L+Cross_W_50) (Cross_L+Hybrid_W/2+Hybrid_L_120/2+Hybrid_W_50, Hybrid_L), closed, covered)
  Bend_3 = polyline(z=H, xy: (Hybrid_W/2+Hybrid_L_120/2+Hybrid_W_50, Hybrid_L+Cross_W_40+Cross_L_50) (Hybrid_W/2+Hybrid_L_120/2+Hybrid_W_50, Hybrid_L+Cross_W_50+Cross_W_40+Cross_L_50) (Hybrid_W/2+Hybrid_L_120/2, Hybrid_L+Cross_W_50+Cross_W_40+Cross_L_50) (Hybrid_W/2+Hybrid_L_120/2+Hybrid_W_50, Hybrid_L+Cross_W_40+Cross_L_50), closed, covered)
  Bend_4 = polyline(z=H, xy: (Cross_L+Hybrid_W/2+Hybrid_L_120/2+Hybrid_W_50, Hybrid_L+Cross_L_50+Cross_W_40) (Cross_L+Hybrid_W/2+Hybrid_L_120/2+Hybrid_W_50, Hybrid_L+Cross_L_50+Cross_W_50+Cross_W_40) (Cross_L+Hybrid_W/2+Hybrid_L_120/2+2*Hybrid_W_50, Hybrid_L+Cross_L_50+Cross_W_50+Cross_W_40) (Cross_L+Hybrid_W/2+Hybrid_L_120/2+Hybrid_W_50, Hybrid_L+Cross_L_50+Cross_W_40), closed, covered)
  Bend_5 = polyline(z=H, xy: (Hybrid_W/2+Hybrid_L_120/2+Hybrid_W_50, Hybrid_L+Cross_W_40+Cross_W_50+Cross_L_50+Hybrid_L) (Hybrid_W/2+Hybrid_L_120/2+Hybrid_W_50, Hybrid_L+Cross_W_40+2*Cross_W_50+Cross_L_50+Hybrid_L) (Hybrid_W/2+Hybrid_L_120/2, Hybrid_L+Cross_W_40+Cross_W_50+Cross_L_50+Hybrid_L) (Hybrid_W/2+Hybrid_L_120/2+Hybrid_W_50, Hybrid_L+Cross_W_40+Cross_W_50+Cross_L_50+Hybrid_L), closed, covered)
  Bend_6 = polyline(z=H, xy: (Cross_L+Hybrid_W/2+Hybrid_L_120/2+Hybrid_W_50, 2*Hybrid_L+Cross_L_50+Cross_W_50+Cross_W_40) (Cross_L+Hybrid_W/2+Hybrid_L_120/2+Hybrid_W_50, 2*Hybrid_L+Cross_L_50+2*Cross_W_50+Cross_W_40) (Cross_L+Hybrid_W/2+Hybrid_L_120/2+2*Hybrid_W_50, 2*Hybrid_L+Cross_L_50+Cross_W_50+Cross_W_40) (Cross_L+Hybrid_W/2+Hybrid_L_120/2+Hybrid_W_50, 2*Hybrid_L+Cross_L_50+Cross_W_50+Cross_W_40), closed, covered)
  Phaser45_top = rectangle(corner=(Phase_W/2-Phase_W_50/2, 0mm, H), x_size=Phase_W_50, y_size=Phase_a)
  TL5 = rectangle(corner=(Phase_W/2-Phase_W_50/2, Phase_a+2*Phase_W_50+Phase_c, H), x_size=Phase_W_50, y_size=Phase_a)
  TL4 = rectangle(corner=(Phase_W/2-Phase_W_50/2-Phase_b, Phase_a+Phase_W_50+Phase_c, H), x_size=Phase_b, y_size=Phase_W_50)
  TL3 = rectangle(corner=(Phase_W/2-Phase_W_50/2-Phase_b, Phase_a+Phase_W_50, H), x_size=-Phase_W_50, y_size=Phase_c)
  TL2 = rectangle(corner=(Phase_W/2-Phase_W_50/2, Phase_a, H), x_size=-Phase_b, y_size=Phase_W_50)
  Bend10 = polyline(z=H, xy: (Phase_W/2-Phase_W_50/2, Phase_a+Phase_W_50+Phase_c) (Phase_W/2+Phase_W_50/2, Phase_a+2*Phase_W_50+Phase_c) (Phase_W/2-Phase_W_50/2, Phase_a+2*Phase_W_50+Phase_c) (Phase_W/2-Phase_W_50/2, Phase_a+Phase_W_50+Phase_c), closed, covered)
  Bend9 = polyline(z=H, xy: (Phase_W/2-1.5*Phase_W_50-Phase_b, Phase_a+Phase_W_50+Phase_c) (Phase_W/2-Phase_W_50/2-Phase_b, Phase_a+2*Phase_W_50+Phase_c) (Phase_W/2-Phase_W_50/2-Phase_b, Phase_a+Phase_W_50+Phase_c) (Phase_W/2-1.5*Phase_W_50-Phase_b, Phase_a+Phase_W_50+Phase_c), closed, covered)
  Bend8 = polyline(z=H, xy: (Phase_W/2-Phase_W_50/2-Phase_b, Phase_a) (Phase_W/2-1.5*Phase_W_50-Phase_b, Phase_a+Phase_W_50) (Phase_W/2-Phase_W_50/2-Phase_b, Phase_a+Phase_W_50) (Phase_W/2-Phase_W_50/2-Phase_b, Phase_a), closed, covered)
  Bend7 = polyline(z=H, xy: (Phase_W/2+Phase_W_50/2, Phase_a) (Phase_W/2-Phase_W_50/2, Phase_a+Phase_W_50) (Phase_W/2-Phase_W_50/2, Phase_a) (Phase_W/2+Phase_W_50/2, Phase_a), closed, covered)
  Phaser45_top.unite(TL5, TL4, TL3, TL2, Bend10, Bend9, Bend8, Bend7)
  Phaser45_top.move(-Phase_W/2+Phase_W_50/2+Hybrid_W/2-Hybrid_L_120/2-Hybrid_W_50, Hybrid_L, 0mm)
  Phaser45_down = Phaser45_top.duplicate_mirror(point=(Hybrid_W/2+Hybrid_L_120/2+Hybrid_W_50+Cross_L/2, Hybrid_L+Cross_W_50+Cross_L_50/2, 0mm), normal=(1mm, 0mm, 0mm))
  Feed_6 = rectangle(corner=(Hybrid_W/2+Hybrid_L_120/2+Hybrid_W_50, 2*Hybrid_L+2*Cross_W_50+2*Cross_W_40+2*Cross_L_50, H), x_size=-Cross_W_50, y_size=L_feed6)
  Feed_7 = rectangle(corner=(Cross_L+Hybrid_W/2+Hybrid_L_120/2+Hybrid_W_50, 2*Hybrid_L+2*Cross_L_50+2*Cross_W_50+2*Cross_W_40, H), x_size=Cross_W_50, y_size=L_feed7)
  Feed_5 = rectangle(corner=(Hybrid_W/2-Hybrid_L_120/2-2*exten_W_50-2*exten_c, 2*Hybrid_L+2*Cross_W_50+2*Cross_W_40+2*Cross_L_50, H), x_size=-Hybrid_W_50, y_size=L_feed5)
  Feed_8 = rectangle(corner=(Cross_L+Hybrid_W/2+1.5*Hybrid_L_120+2*Hybrid_W_50+2*exten_c+2*exten_W_50, 2*Hybrid_L+2*Cross_W_50+2*Cross_W_40+2*Cross_L_50, H), x_size=Hybrid_W_50, y_size=L_feed8)
  Bend_7 = polyline(z=H, xy: (Hybrid_W/2+Hybrid_L_120/2+Hybrid_W_50, 2*Hybrid_L+Cross_W_50+2*Cross_W_40+2*Cross_L_50) (Hybrid_W/2+Hybrid_L_120/2+Hybrid_W_50, 2*Hybrid_L+2*Cross_W_50+2*Cross_W_40+2*Cross_L_50) (Hybrid_W/2+Hybrid_L_120/2, 2*Hybrid_L+2*Cross_W_50+2*Cross_W_40+2*Cross_L_50) (Hybrid_W/2+Hybrid_L_120/2+Hybrid_W_50, 2*Hybrid_L+Cross_W_50+2*Cross_W_40+2*Cross_L_50), closed, covered)
  Bend_8 = polyline(z=H, xy: (Cross_L+Hybrid_W/2+Hybrid_L_120/2+Hybrid_W_50, 2*Hybrid_L+2*Cross_L_50+Cross_W_50+2*Cross_W_40) (Cross_L+Hybrid_W/2+Hybrid_L_120/2+Hybrid_W_50, 2*Hybrid_L+2*Cross_L_50+2*Cross_W_50+2*Cross_W_40) (Cross_L+Hybrid_W/2+Hybrid_L_120/2+2*Hybrid_W_50, 2*Hybrid_L+2*Cross_L_50+2*Cross_W_50+2*Cross_W_40) (Cross_L+Hybrid_W/2+Hybrid_L_120/2+Hybrid_W_50, 2*Hybrid_L+2*Cross_L_50+Cross_W_50+2*Cross_W_40), closed, covered)
  coordinate_system RelativeCS1 = origin=(Cross_W/2+Cross_L_50/2+Cross_W_40/2+Cross_W_50/2, 0mm, 0.8mm) x=(1mm, 0mm, 0mm) y=(0mm, 1mm, 0mm)
  Top = rectangle(corner=(exten_W-exten_W_50-exten_pad, 0mm, H), x_size=exten_W_50, y_size=exten_a)
  TL6 = rectangle(corner=(exten_W-2*exten_W_50-exten_pad-2*exten_c, exten_a, H), x_size=-exten_W_50, y_size=exten_a)
  TL9 = rectangle(corner=(exten_W-2*exten_W_50-exten_pad-2*exten_c, exten_a-exten_b, H), x_size=-exten_W_50, y_size=exten_b)
  TL10 = rectangle(corner=(exten_W-2*exten_W_50-exten_pad-exten_c, exten_a-exten_b, H), x_size=-exten_c, y_size=-exten_W_50)
  TL8 = rectangle(corner=(exten_W-exten_W_50-exten_pad-exten_c, exten_a, H), x_size=-exten_W_50, y_size=-exten_b)
  TL7 = rectangle(corner=(exten_W-exten_W_50-exten_pad, exten_a, H), x_size=-exten_c, y_size=exten_W_50)
  Bend4 = polyline(z=H, xy: (exten_W-2*exten_W_50-exten_pad-2*exten_c, exten_a-exten_b-exten_W_50) (exten_W-2*exten_W_50-exten_pad-2*exten_c, exten_a-exten_b) (exten_W-3*exten_W_50-exten_pad-2*exten_c, exten_a-exten_b) (exten_W-2*exten_W_50-exten_pad-2*exten_c, exten_a-exten_b-exten_W_50), closed, covered)
  Bend3 = polyline(z=H, xy: (exten_W-2*exten_W_50-exten_pad-exten_c, exten_a-exten_b) (exten_W-2*exten_W_50-exten_pad-exten_c, exten_a-exten_b-exten_W_50) (exten_W-exten_W_50-exten_pad-exten_c, exten_a-exten_b) (exten_W-2*exten_W_50-exten_pad-exten_c, exten_a-exten_b), closed, covered)
  Bend2 = polyline(z=H, xy: (exten_W-exten_W_50-exten_pad-exten_c, exten_a) (exten_W-2*exten_W_50-exten_pad-exten_c, exten_a) (exten_W-exten_W_50-exten_pad-exten_c, exten_a+exten_W_50) (exten_W-exten_W_50-exten_pad-exten_c, exten_a), closed, covered)
  Bend1 = polyline(z=H, xy: (exten_W-exten_pad, exten_a) (exten_W-exten_W_50-exten_pad, exten_a+exten_W_50) (exten_W-exten_W_50-exten_pad, exten_a) (exten_W-exten_pad, exten_a), closed, covered)
  Top.unite(TL6, TL9, TL10, TL8, TL7, Bend4, Bend3, Bend2, Bend1)
  Top.move(-exten_W+exten_pad+exten_W_50+Hybrid_W/2-Hybrid_L_120/2-Hybrid_W_50, 2*Hybrid_L+Cross_W_40+Cross_W_50+Cross_L_50, 0mm)
  Crossover1 = rectangle(corner=(Cross_W/2-Cross_L_64/2-Cross_W_40/2-Cross_W_50/2, 0mm, H), x_size=Cross_W_50, y_size=Cross_L_feed+Cross_W_50/2)
  feed6 = rectangle(corner=(Cross_W/2-Cross_L_64/2-Cross_W_40/2-Cross_W_50/2, Cross_L, H), x_size=Cross_W_50, y_size=-Cross_L_feed-Cross_W_50/2)
  feed7 = rectangle(corner=(Cross_W/2+Cross_L_64/2+Cross_W_40/2+Cross_W_50/2, Cross_L, H), x_size=-Cross_W_50, y_size=-Cross_L_feed-Cross_W_50/2)
  feed5 = rectangle(corner=(Cross_W/2+Cross_L_64/2+Cross_W_40/2+Cross_W_50/2, 0mm, H), x_size=-Cross_W_50, y_size=Cross_L_feed+Cross_W_50/2)
  parallel1 = rectangle(corner=(Cross_W/2-Cross_L_64/2, Cross_L_feed, H), x_size=Cross_L_50, y_size=Cross_W_50)
  parallel2 = rectangle(corner=(Cross_W/2-Cross_L_64/2, Cross_L_feed+Cross_W_50/2+Cross_L_40-Cross_W_64/2, H), x_size=Cross_L_64, y_size=Cross_W_64)
  parallel3 = rectangle(corner=(Cross_W/2-Cross_L_64/2, Cross_L_feed+Cross_W_50/2+Cross_L_40+Cross_L_64-Cross_W_64/2, H), x_size=Cross_L_64, y_size=Cross_W_64)
  parallel4 = rectangle(corner=(Cross_W/2-Cross_L_64/2, Cross_L_feed+2*Cross_L_40+Cross_L_64, H), x_size=Cross_L_50, y_size=Cross_W_50)
  Polyline1 = polyline(z=H, xy: (Cross_W/2-Cross_L_50/2, Cross_L_feed+Cross_W_50/2) (Cross_W/2-Cross_L_50/2-Cross_W_40/2+Cross_W_50/2, Cross_L_feed+Cross_W_50/2) (Cross_W/2-Cross_L_50/2-Cross_W_40/2+Cross_W_50/2, Cross_L_feed) (Cross_W/2-Cross_L_50/2, Cross_L_feed) (Cross_W/2-Cross_L_50/2, Cross_L_feed+Cross_W_50/2), closed, covered)
  Polyline2 = polyline(z=H, xy: (Cross_W/2+Cross_L_50/2, Cross_L_feed+Cross_W_50/2) (Cross_W/2+Cross_L_50/2+Cross_W_40/2-Cross_W_50/2, Cross_L_feed+Cross_W_50/2) (Cross_W/2+Cross_L_50/2+Cross_W_40/2-Cross_W_50/2, Cross_L_feed) (Cross_W/2+Cross_L_50/2, Cross_L_feed) (Cross_W/2+Cross_L_50/2, Cross_L_feed+Cross_W_50/2), closed, covered)
  Polyline3 = polyline(z=H, xy: (Cross_W/2-Cross_L_50/2, Cross_L-Cross_L_feed-Cross_W_50/2) (Cross_W/2-Cross_L_50/2, Cross_L-Cross_L_feed) (Cross_W/2-Cross_L_50/2-Cross_W_40/2+Cross_W_50/2, Cross_L-Cross_L_feed) (Cross_W/2-Cross_L_50/2-Cross_W_40/2+Cross_W_50/2, Cross_L-Cross_L_feed-Cross_W_50/2) (Cross_W/2-Cross_L_50/2, Cross_L-Cross_L_feed-Cross_W_50/2), closed, covered)
  Polyline4 = polyline(z=H, xy: (Cross_W/2+Cross_L_50/2, Cross_L-Cross_L_feed-Cross_W_50/2) (Cross_W/2+Cross_L_50/2+Cross_W_40/2-Cross_W_50/2, Cross_L-Cross_L_feed-Cross_W_50/2) (Cross_W/2+Cross_L_50/2+Cross_W_40/2-Cross_W_50/2, Cross_L-Cross_L_feed) (Cross_W/2+Cross_L_50/2, Cross_L-Cross_L_feed) (Cross_W/2+Cross_L_50/2, Cross_L-Cross_L_feed-Cross_W_50/2), closed, covered)
  series1_1 = rectangle(corner=(Cross_W/2-Cross_L_64/2, Cross_L_feed+Cross_W_50/2, H), x_size=-Cross_W_40, y_size=Cross_L_40)
  series1_2 = rectangle(corner=(Cross_W/2+Cross_L_64/2, Cross_L_feed+Cross_W_50/2, H), x_size=Cross_W_40, y_size=Cross_L_40)
  series2_1 = rectangle(corner=(Cross_W/2-Cross_L_64/2, Cross_L_feed+Cross_W_50/2+Cross_L_40, H), x_size=-Cross_W_64, y_size=Cross_L_64)
  series2_2 = rectangle(corner=(Cross_W/2+Cross_L_64/2, Cross_L_feed+Cross_W_50/2+Cross_L_40, H), x_size=Cross_W_64, y_size=Cross_L_64)
  series3_1 = rectangle(corner=(Cross_W/2-Cross_L_64/2, Cross_L_feed+Cross_W_50/2+Cross_L_40+Cross_L_64, H), x_size=-Cross_W_40, y_size=Cross_L_40)
  series3_2 = rectangle(corner=(Cross_W/2+Cross_L_64/2, Cross_L_feed+Cross_W_50/2+Cross_L_40+Cross_L_64, H), x_size=Cross_W_40, y_size=Cross_L_40)
  Crossover1.unite(feed6, feed7, feed5, parallel1..parallel4, Polyline1..Polyline4, series1_1, series1_2, series2_1, series2_2, series3_1, series3_2)
  Crossover1.rotate(axis=Z, angle=-90deg) in RelativeCS1
  Crossover1.move(Hybrid_W/2+Hybrid_L_120/2+Hybrid_W_50-Cross_W/2-Cross_L_50/2-Cross_W_50/2-Cross_W_40/2, Hybrid_L, 0mm) in RelativeCS1
  Crossover2 = Crossover1.duplicate_along_line(step=(0mm, Hybrid_L+Cross_L_50+Cross_W_50+Cross_W_40, 0mm), total=2) in RelativeCS1
  Top_1 = Top.duplicate_mirror(point=(Hybrid_W/2+Hybrid_L_120/2+Hybrid_W_50+Cross_L/2, 2*Hybrid_L+Cross_W_40+Cross_W_50+Cross_L_50, 0mm), normal=(1mm, 0mm, 0mm))
  Hybrid1 [copper] = rectangle(corner=(Hybrid_W/2-Hybrid_L_120/2, 0mm, H), x_size=-Hybrid_W_50, y_size=Hybrid_L_feed+Hybrid_W_120/2)
  feed2 = rectangle(corner=(Hybrid_W/2-Hybrid_L_120/2, Hybrid_L, H), x_size=-Hybrid_W_50, y_size=-Hybrid_L_feed-Hybrid_W_120/2)
  feed3 = rectangle(corner=(Hybrid_W/2+Hybrid_L_120/2, Hybrid_L, H), x_size=Hybrid_W_50, y_size=-Hybrid_L_feed-Hybrid_W_120/2)
  feed4 = rectangle(corner=(Hybrid_W/2+Hybrid_L_120/2, 0mm, H), x_size=Hybrid_W_50, y_size=Hybrid_L_feed+Hybrid_W_120/2)
  parallel5 = rectangle(corner=(Hybrid_W/2-Hybrid_L_120/2, Hybrid_L_feed, H), x_size=Hybrid_L_120, y_size=Hybrid_W_120)
  parallel6 = rectangle(corner=(Hybrid_W/2-Hybrid_L_120/2, Hybrid_L_feed+Hybrid_L_50+Hybrid_W_120/2-Hybrid_W_70/2, H), x_size=Hybrid_L_120, y_size=Hybrid_W_70)
  parallel7 = rectangle(corner=(Hybrid_W/2-Hybrid_L_120/2, Hybrid_L_feed+2*Hybrid_L_50, H), x_size=Hybrid_L_120, y_size=Hybrid_W_120)
  series1_3 = rectangle(corner=(Hybrid_W/2-Hybrid_L_120/2, Hybrid_L_feed+Hybrid_W_120/2, H), x_size=-Hybrid_W_50, y_size=Hybrid_L_50)
  series1_4 = rectangle(corner=(Hybrid_W/2+Hybrid_L_120/2, Hybrid_L_feed+Hybrid_W_120/2, H), x_size=Hybrid_W_50, y_size=Hybrid_L_50)
  series2_3 = rectangle(corner=(Hybrid_W/2-Hybrid_L_120/2, Hybrid_L_feed+Hybrid_W_120/2+Hybrid_L_50, H), x_size=-Hybrid_W_50, y_size=Hybrid_L_50)
  series2_4 = rectangle(corner=(Hybrid_W/2+Hybrid_L_120/2, Hybrid_L_feed+Hybrid_W_120/2+Hybrid_L_50, H), x_size=Hybrid_W_50, y_size=Hybrid_L_50)
  Hybrid1.unite(feed2, feed3, feed4, parallel5, parallel6, parallel7, series1_3, series1_4, series2_3, series2_4)
  Hybrid2 = Hybrid1.duplicate_along_line(step=(0mm, Hybrid_L+Cross_L_50+Cross_W_50+Cross_W_40, 0mm), total=2)
  Hybrid3 = Hybrid1.duplicate_along_line(step=(Cross_L+Hybrid_L_120+2*Hybrid_W_50, 0mm, 0mm), total=2)
  Hybrid4 = Hybrid2.duplicate_along_line(step=(Cross_L+Hybrid_L_120+2*Hybrid_W_50, 0mm, 0mm), total=2)
  Hybrid1.unite(Hybrid2, Hybrid3, Hybrid4, Phaser45_down, Phaser45_top, Top, Top_1, Bend_1..Bend_8, Crossover1, Crossover2, Feed_5..Feed_8)
  Hybrid1.thicken(0.017mm)
boundaries and excitations:
  PerfE1: Perfect E Objects=Ground
  Rad1: Radiation Objects=Box2
  1: Lumped Port Faces=Port1.face Modes{Mode1{IntLine{middle of Port1.edge(z opposite corner) -> middle of Port1.edge(z at corner)} CharImp=Zpi RenormImp=50ohm}} Impedance=50ohm
  2: Lumped Port Objects=Port2 Modes{Mode1{IntLine{middle of Port2.edge(z opposite corner) -> middle of Port2.edge(z at corner)} CharImp=Zpi RenormImp=50ohm}} Impedance=50ohm
  3: Lumped Port Objects=Port3 Modes{Mode1{IntLine{middle of Port3.edge(z opposite corner) -> middle of Port3.edge(z at corner)} CharImp=Zpi RenormImp=50ohm}} Impedance=50ohm
  4: Lumped Port Objects=Port4 Modes{Mode1{IntLine{middle of Port4.edge(z opposite corner) -> middle of Port4.edge(z at corner)} CharImp=Zpi RenormImp=50ohm}} Impedance=50ohm
  5: Lumped Port Objects=Port5 Modes{Mode1{IntLine{middle of Port5.edge(z opposite corner) -> middle of Port5.edge(z at corner)} CharImp=Zpi RenormImp=50ohm}} Impedance=50ohm
  6: Lumped Port Objects=Port6 Modes{Mode1{IntLine{middle of Port6.edge(z opposite corner) -> middle of Port6.edge(z at corner)} CharImp=Zpi RenormImp=50ohm}} Impedance=50ohm
  7: Lumped Port Objects=Port7 Modes{Mode1{IntLine{middle of Port7.edge(z opposite corner) -> middle of Port7.edge(z at corner)} CharImp=Zpi RenormImp=50ohm}} Impedance=50ohm
  8: Lumped Port Objects=Port8 Modes{Mode1{IntLine{middle of Port8.edge(z opposite corner) -> middle of Port8.edge(z at corner)} CharImp=Zpi RenormImp=50ohm}} Impedance=50ohm
setups:
  Setup1: HfssDriven Frequency=5GHz MaxDeltaS=0.02 MaximumPasses=25 MinimumPasses=1 MinimumConvergedPasses=1 PercentRefinement=30 BasisOrder=1 PortAccuracy=2
    sweep Sweep: 4GHz to 6GHz step 0.01GHz; Type=Fast SaveFields
source amplitudes:
  1:1: 1W 0deg
  2:1, 3:1, 4:1, 5:1, 6:1, 7:1, 8:1: 0W 0deg
optimetrics:
  ParametricSetup1: Parametric disabled Sim._Setups=[Setup1]
    sweep L_feed5: LIN 2mm 8mm 0.25mm
output variables:
  phase_diff_5_6 = ang_deg(S(5,1))-ang_deg(S(6,1))
  phase_diff_6_7 = ang_deg(S(6,1))-ang_deg(S(7,1))
  phase_diff_7_8 = ang_deg(S(7,1))-ang_deg(S(8,1))
reports:
  S-Parameters: dB(S(1,1)), dB(S(2,1)), dB(S(3,1)), dB(S(4,1)) vs Freq on Setup1 : Sweep; markers MX1 at x=5.0029718e+09, MY1 at y=-14.975
  Insertion Loss: dB(S(5,1)), dB(S(6,1)), dB(S(7,1)), dB(S(8,1)) vs Freq on Setup1 : Sweep; markers MX1 at x=5.0029718e+09
  S Parameter Plot 3: ang_deg(S(5,1)), ang_deg(S(6,1)), ang_deg(S(7,1)), ang_deg(S(8,1)) vs Freq on Setup1 : Sweep; markers MX1 at x=5e+09
  Output Variables Plot 1: phase_diff_5_6, phase_diff_6_7, phase_diff_7_8 vs Freq on Setup1 : Sweep; markers MX1 at x=5e+09
  S Parameter Plot 4: ang_deg(S(2,1)) vs Freq on Setup1 : Sweep [L_feed5=all]; markers MX1 at x=4.9999383e+09

design Butler_Matrix_Arr (HFSS, DrivenModal, model units mm)
variables:
  H = 0.8mm
  W_50 = 1.7645mm
  Hybrid_L_35 = 7.82mm
  Hybrid_L_50 = 7.05mm
  Hybrid_L = 2*Hybrid_L_feed+Hybrid_W_120+2*Hybrid_L_50
  Hybrid_W = 25mm
  Hybrid_W_50 = 1.7645mm
  Hybrid_W_35 = 2.985mm
  Hybrid_L_feed = 5mm
  Cross_L_50 = Cross_L_64
  Cross_W_50 = 1.76772mm
  Cross_L_feed = 5mm
  Cross_L = 2*Cross_L_feed+2*Cross_L_40+Cross_L_64+Cross_W_50
  Cross_W = 25mm
  Phase_c = 6.920022mm
  Phase_W = 40mm
  Phase_W_50 = 1.7645mm
  Phase_a = 1.5mm
  Phase_b = 9.3mm
  L_feed6 = L_feed5
  L_feed7 = L_feed5
  L_feed5 = 7.1mm
  L = 2*Hybrid_L+2*Cross_L_50+2*Cross_W_50+2*Cross_W_40+L_feed5+La
  L_feed8 = L_feed5
  W = Cross_L+6*Hybrid_W_50+2*Hybrid_L_50+2*Phase_b
  exten_b = 4mm
  exten_W_50 = 1.7645mm
  exten_a = 6.724511mm
  exten_c = 12.5mm
  exten_W = 30mm
  exten_L = 2*exten_a+2*exten_W_50+exten_c
  Phase_L = 2*Phase_a+2*Phase_W_50+Phase_c
  L_feed = 5mm
  L_50 = 9.2mm
  exten_pad = 6mm
  Cross_L_64 = 9.348402mm
  Cross_W_64 = 1.1734mm
  Cross_L_40 = 7.9149mm
  Cross_W_40 = 2.3329mm
  Hybrid_W_120 = 0.2532mm
  Hybrid_L_120 = 8.0138mm
  Hyrid_L_feed = 5mm
  Hybrid_W_70 = 0.95079mm
  Wa = Wp+6*hg
  hg = 1.9298mm
  Wp = 19.9mm
  La = Lp+6*hg
  Lp = 15.6mm
  depth = 4.842mm
  S = 4.005mm
geometry:
  Box1 [Rogers RO4003 (tm)] = box(corner=(-35mm, 0mm, 0mm), size=(W+62.292mm, L, H))
  Ground = object_from(Box1.face(-z))
  Port2 = rectangle(corner=(Hybrid_W/2+Hybrid_L_120/2, 0mm, H), z_size=-H, x_size=Hybrid_W_50)
  Port1 = rectangle(corner=(Hybrid_W/2-Hybrid_L_120/2, 0mm, H), z_size=-H, x_size=-Hybrid_W_50)
  Port3 = rectangle(corner=(Cross_L+Hybrid_W/2+Hybrid_L_120/2+Hybrid_W_50, 0mm, H), z_size=-H, x_size=Hybrid_W_50)
  Port4 = rectangle(corner=(Cross_L+Hybrid_W/2+1.5*Hybrid_L_120+2*Hybrid_W_50, 0mm, H), z_size=-H, x_size=Hybrid_W_50)
  Box2 [vacuum] = box(corner=(-45mm, -10mm, -10mm), size=(W+90mm-2*3.854mm, 20mm+L, 20mm))
  Bend_1 = polyline(z=H, xy: (Hybrid_W/2+Hybrid_L_120/2+Hybrid_W_50, Hybrid_L) (Hybrid_W/2+Hybrid_L_120/2+Hybrid_W_50, Hybrid_L+Cross_W_50) (Hybrid_W/2+Hybrid_L_120/2, Hybrid_L) (Hybrid_W/2+Hybrid_L_120/2+Hybrid_W_50, Hybrid_L), closed, covered)
  Bend_2 = polyline(z=H, xy: (Cross_L+Hybrid_W/2+Hybrid_L_120/2+Hybrid_W_50, Hybrid_L) (Cross_L+Hybrid_W/2+Hybrid_L_120/2+2*Hybrid_W_50, Hybrid_L) (Cross_L+Hybrid_W/2+Hybrid_L_120/2+Hybrid_W_50, Hybrid_L+Cross_W_50) (Cross_L+Hybrid_W/2+Hybrid_L_120/2+Hybrid_W_50, Hybrid_L), closed, covered)
  Bend_3 = polyline(z=H, xy: (Hybrid_W/2+Hybrid_L_120/2+Hybrid_W_50, Hybrid_L+Cross_W_40+Cross_L_50) (Hybrid_W/2+Hybrid_L_120/2+Hybrid_W_50, Hybrid_L+Cross_W_50+Cross_W_40+Cross_L_50) (Hybrid_W/2+Hybrid_L_120/2, Hybrid_L+Cross_W_50+Cross_W_40+Cross_L_50) (Hybrid_W/2+Hybrid_L_120/2+Hybrid_W_50, Hybrid_L+Cross_W_40+Cross_L_50), closed, covered)
  Bend_4 = polyline(z=H, xy: (Cross_L+Hybrid_W/2+Hybrid_L_120/2+Hybrid_W_50, Hybrid_L+Cross_L_50+Cross_W_40) (Cross_L+Hybrid_W/2+Hybrid_L_120/2+Hybrid_W_50, Hybrid_L+Cross_L_50+Cross_W_50+Cross_W_40) (Cross_L+Hybrid_W/2+Hybrid_L_120/2+2*Hybrid_W_50, Hybrid_L+Cross_L_50+Cross_W_50+Cross_W_40) (Cross_L+Hybrid_W/2+Hybrid_L_120/2+Hybrid_W_50, Hybrid_L+Cross_L_50+Cross_W_40), closed, covered)
  Bend_5 = polyline(z=H, xy: (Hybrid_W/2+Hybrid_L_120/2+Hybrid_W_50, Hybrid_L+Cross_W_40+Cross_W_50+Cross_L_50+Hybrid_L) (Hybrid_W/2+Hybrid_L_120/2+Hybrid_W_50, Hybrid_L+Cross_W_40+2*Cross_W_50+Cross_L_50+Hybrid_L) (Hybrid_W/2+Hybrid_L_120/2, Hybrid_L+Cross_W_40+Cross_W_50+Cross_L_50+Hybrid_L) (Hybrid_W/2+Hybrid_L_120/2+Hybrid_W_50, Hybrid_L+Cross_W_40+Cross_W_50+Cross_L_50+Hybrid_L), closed, covered)
  Bend_6 = polyline(z=H, xy: (Cross_L+Hybrid_W/2+Hybrid_L_120/2+Hybrid_W_50, 2*Hybrid_L+Cross_L_50+Cross_W_50+Cross_W_40) (Cross_L+Hybrid_W/2+Hybrid_L_120/2+Hybrid_W_50, 2*Hybrid_L+Cross_L_50+2*Cross_W_50+Cross_W_40) (Cross_L+Hybrid_W/2+Hybrid_L_120/2+2*Hybrid_W_50, 2*Hybrid_L+Cross_L_50+Cross_W_50+Cross_W_40) (Cross_L+Hybrid_W/2+Hybrid_L_120/2+Hybrid_W_50, 2*Hybrid_L+Cross_L_50+Cross_W_50+Cross_W_40), closed, covered)
  Phaser45_top = rectangle(corner=(Phase_W/2-Phase_W_50/2, 0mm, H), x_size=Phase_W_50, y_size=Phase_a)
  TL5 = rectangle(corner=(Phase_W/2-Phase_W_50/2, Phase_a+2*Phase_W_50+Phase_c, H), x_size=Phase_W_50, y_size=Phase_a)
  TL4 = rectangle(corner=(Phase_W/2-Phase_W_50/2-Phase_b, Phase_a+Phase_W_50+Phase_c, H), x_size=Phase_b, y_size=Phase_W_50)
  TL3 = rectangle(corner=(Phase_W/2-Phase_W_50/2-Phase_b, Phase_a+Phase_W_50, H), x_size=-Phase_W_50, y_size=Phase_c)
  TL2 = rectangle(corner=(Phase_W/2-Phase_W_50/2, Phase_a, H), x_size=-Phase_b, y_size=Phase_W_50)
  Bend10 = polyline(z=H, xy: (Phase_W/2-Phase_W_50/2, Phase_a+Phase_W_50+Phase_c) (Phase_W/2+Phase_W_50/2, Phase_a+2*Phase_W_50+Phase_c) (Phase_W/2-Phase_W_50/2, Phase_a+2*Phase_W_50+Phase_c) (Phase_W/2-Phase_W_50/2, Phase_a+Phase_W_50+Phase_c), closed, covered)
  Bend9 = polyline(z=H, xy: (Phase_W/2-1.5*Phase_W_50-Phase_b, Phase_a+Phase_W_50+Phase_c) (Phase_W/2-Phase_W_50/2-Phase_b, Phase_a+2*Phase_W_50+Phase_c) (Phase_W/2-Phase_W_50/2-Phase_b, Phase_a+Phase_W_50+Phase_c) (Phase_W/2-1.5*Phase_W_50-Phase_b, Phase_a+Phase_W_50+Phase_c), closed, covered)
  Bend8 = polyline(z=H, xy: (Phase_W/2-Phase_W_50/2-Phase_b, Phase_a) (Phase_W/2-1.5*Phase_W_50-Phase_b, Phase_a+Phase_W_50) (Phase_W/2-Phase_W_50/2-Phase_b, Phase_a+Phase_W_50) (Phase_W/2-Phase_W_50/2-Phase_b, Phase_a), closed, covered)
  Bend7 = polyline(z=H, xy: (Phase_W/2+Phase_W_50/2, Phase_a) (Phase_W/2-Phase_W_50/2, Phase_a+Phase_W_50) (Phase_W/2-Phase_W_50/2, Phase_a) (Phase_W/2+Phase_W_50/2, Phase_a), closed, covered)
  Phaser45_top.unite(TL5, TL4, TL3, TL2, Bend10, Bend9, Bend8, Bend7)
  Phaser45_top.move(-Phase_W/2+Phase_W_50/2+Hybrid_W/2-Hybrid_L_120/2-Hybrid_W_50, Hybrid_L, 0mm)
  Phaser45_down = Phaser45_top.duplicate_mirror(point=(Hybrid_W/2+Hybrid_L_120/2+Hybrid_W_50+Cross_L/2, Hybrid_L+Cross_W_50+Cross_L_50/2, 0mm), normal=(1mm, 0mm, 0mm))
  Feed_6 = rectangle(corner=(Hybrid_W/2+Hybrid_L_120/2+Hybrid_W_50, 2*Hybrid_L+2*Cross_W_50+2*Cross_W_40+2*Cross_L_50, H), x_size=-Cross_W_50, y_size=L_feed6)
  Feed_7 = rectangle(corner=(Cross_L+Hybrid_W/2+Hybrid_L_120/2+Hybrid_W_50, 2*Hybrid_L+2*Cross_L_50+2*Cross_W_50+2*Cross_W_40, H), x_size=Cross_W_50, y_size=L_feed7)
  Feed_5 = rectangle(corner=(Hybrid_W/2-Hybrid_L_120/2-2*exten_W_50-2*exten_c, 2*Hybrid_L+2*Cross_W_50+2*Cross_W_40+2*Cross_L_50, H), x_size=-Hybrid_W_50, y_size=L_feed5)
  Feed_8 = rectangle(corner=(Cross_L+Hybrid_W/2+1.5*Hybrid_L_120+2*Hybrid_W_50+2*exten_c+2*exten_W_50, 2*Hybrid_L+2*Cross_W_50+2*Cross_W_40+2*Cross_L_50, H), x_size=Hybrid_W_50, y_size=L_feed8)
  Bend_7 = polyline(z=H, xy: (Hybrid_W/2+Hybrid_L_120/2+Hybrid_W_50, 2*Hybrid_L+Cross_W_50+2*Cross_W_40+2*Cross_L_50) (Hybrid_W/2+Hybrid_L_120/2+Hybrid_W_50, 2*Hybrid_L+2*Cross_W_50+2*Cross_W_40+2*Cross_L_50) (Hybrid_W/2+Hybrid_L_120/2, 2*Hybrid_L+2*Cross_W_50+2*Cross_W_40+2*Cross_L_50) (Hybrid_W/2+Hybrid_L_120/2+Hybrid_W_50, 2*Hybrid_L+Cross_W_50+2*Cross_W_40+2*Cross_L_50), closed, covered)
  Bend_8 = polyline(z=H, xy: (Cross_L+Hybrid_W/2+Hybrid_L_120/2+Hybrid_W_50, 2*Hybrid_L+2*Cross_L_50+Cross_W_50+2*Cross_W_40) (Cross_L+Hybrid_W/2+Hybrid_L_120/2+Hybrid_W_50, 2*Hybrid_L+2*Cross_L_50+2*Cross_W_50+2*Cross_W_40) (Cross_L+Hybrid_W/2+Hybrid_L_120/2+2*Hybrid_W_50, 2*Hybrid_L+2*Cross_L_50+2*Cross_W_50+2*Cross_W_40) (Cross_L+Hybrid_W/2+Hybrid_L_120/2+Hybrid_W_50, 2*Hybrid_L+2*Cross_L_50+Cross_W_50+2*Cross_W_40), closed, covered)
  coordinate_system RelativeCS1 = origin=(Cross_W/2+Cross_L_50/2+Cross_W_40/2+Cross_W_50/2, 0mm, 0.8mm) x=(1mm, 0mm, 0mm) y=(0mm, 1mm, 0mm)
  Top = rectangle(corner=(exten_W-exten_W_50-exten_pad, 0mm, H), x_size=exten_W_50, y_size=exten_a)
  TL6 = rectangle(corner=(exten_W-2*exten_W_50-exten_pad-2*exten_c, exten_a, H), x_size=-exten_W_50, y_size=exten_a)
  TL9 = rectangle(corner=(exten_W-2*exten_W_50-exten_pad-2*exten_c, exten_a-exten_b, H), x_size=-exten_W_50, y_size=exten_b)
  TL10 = rectangle(corner=(exten_W-2*exten_W_50-exten_pad-exten_c, exten_a-exten_b, H), x_size=-exten_c, y_size=-exten_W_50)
  TL8 = rectangle(corner=(exten_W-exten_W_50-exten_pad-exten_c, exten_a, H), x_size=-exten_W_50, y_size=-exten_b)
  TL7 = rectangle(corner=(exten_W-exten_W_50-exten_pad, exten_a, H), x_size=-exten_c, y_size=exten_W_50)
  Bend4 = polyline(z=H, xy: (exten_W-2*exten_W_50-exten_pad-2*exten_c, exten_a-exten_b-exten_W_50) (exten_W-2*exten_W_50-exten_pad-2*exten_c, exten_a-exten_b) (exten_W-3*exten_W_50-exten_pad-2*exten_c, exten_a-exten_b) (exten_W-2*exten_W_50-exten_pad-2*exten_c, exten_a-exten_b-exten_W_50), closed, covered)
  Bend3 = polyline(z=H, xy: (exten_W-2*exten_W_50-exten_pad-exten_c, exten_a-exten_b) (exten_W-2*exten_W_50-exten_pad-exten_c, exten_a-exten_b-exten_W_50) (exten_W-exten_W_50-exten_pad-exten_c, exten_a-exten_b) (exten_W-2*exten_W_50-exten_pad-exten_c, exten_a-exten_b), closed, covered)
  Bend2 = polyline(z=H, xy: (exten_W-exten_W_50-exten_pad-exten_c, exten_a) (exten_W-2*exten_W_50-exten_pad-exten_c, exten_a) (exten_W-exten_W_50-exten_pad-exten_c, exten_a+exten_W_50) (exten_W-exten_W_50-exten_pad-exten_c, exten_a), closed, covered)
  Bend1 = polyline(z=H, xy: (exten_W-exten_pad, exten_a) (exten_W-exten_W_50-exten_pad, exten_a+exten_W_50) (exten_W-exten_W_50-exten_pad, exten_a) (exten_W-exten_pad, exten_a), closed, covered)
  Top.unite(TL6, TL9, TL10, TL8, TL7, Bend4, Bend3, Bend2, Bend1)
  Top.move(-exten_W+exten_pad+exten_W_50+Hybrid_W/2-Hybrid_L_120/2-Hybrid_W_50, 2*Hybrid_L+Cross_W_40+Cross_W_50+Cross_L_50, 0mm)
  Crossover1 = rectangle(corner=(Cross_W/2-Cross_L_64/2-Cross_W_40/2-Cross_W_50/2, 0mm, H), x_size=Cross_W_50, y_size=Cross_L_feed+Cross_W_50/2)
  feed6 = rectangle(corner=(Cross_W/2-Cross_L_64/2-Cross_W_40/2-Cross_W_50/2, Cross_L, H), x_size=Cross_W_50, y_size=-Cross_L_feed-Cross_W_50/2)
  feed7 = rectangle(corner=(Cross_W/2+Cross_L_64/2+Cross_W_40/2+Cross_W_50/2, Cross_L, H), x_size=-Cross_W_50, y_size=-Cross_L_feed-Cross_W_50/2)
  feed5 = rectangle(corner=(Cross_W/2+Cross_L_64/2+Cross_W_40/2+Cross_W_50/2, 0mm, H), x_size=-Cross_W_50, y_size=Cross_L_feed+Cross_W_50/2)
  parallel1 = rectangle(corner=(Cross_W/2-Cross_L_64/2, Cross_L_feed, H), x_size=Cross_L_50, y_size=Cross_W_50)
  parallel2 = rectangle(corner=(Cross_W/2-Cross_L_64/2, Cross_L_feed+Cross_W_50/2+Cross_L_40-Cross_W_64/2, H), x_size=Cross_L_64, y_size=Cross_W_64)
  parallel3 = rectangle(corner=(Cross_W/2-Cross_L_64/2, Cross_L_feed+Cross_W_50/2+Cross_L_40+Cross_L_64-Cross_W_64/2, H), x_size=Cross_L_64, y_size=Cross_W_64)
  parallel4 = rectangle(corner=(Cross_W/2-Cross_L_64/2, Cross_L_feed+2*Cross_L_40+Cross_L_64, H), x_size=Cross_L_50, y_size=Cross_W_50)
  Polyline1 = polyline(z=H, xy: (Cross_W/2-Cross_L_50/2, Cross_L_feed+Cross_W_50/2) (Cross_W/2-Cross_L_50/2-Cross_W_40/2+Cross_W_50/2, Cross_L_feed+Cross_W_50/2) (Cross_W/2-Cross_L_50/2-Cross_W_40/2+Cross_W_50/2, Cross_L_feed) (Cross_W/2-Cross_L_50/2, Cross_L_feed) (Cross_W/2-Cross_L_50/2, Cross_L_feed+Cross_W_50/2), closed, covered)
  Polyline2 = polyline(z=H, xy: (Cross_W/2+Cross_L_50/2, Cross_L_feed+Cross_W_50/2) (Cross_W/2+Cross_L_50/2+Cross_W_40/2-Cross_W_50/2, Cross_L_feed+Cross_W_50/2) (Cross_W/2+Cross_L_50/2+Cross_W_40/2-Cross_W_50/2, Cross_L_feed) (Cross_W/2+Cross_L_50/2, Cross_L_feed) (Cross_W/2+Cross_L_50/2, Cross_L_feed+Cross_W_50/2), closed, covered)
  Polyline3 = polyline(z=H, xy: (Cross_W/2-Cross_L_50/2, Cross_L-Cross_L_feed-Cross_W_50/2) (Cross_W/2-Cross_L_50/2, Cross_L-Cross_L_feed) (Cross_W/2-Cross_L_50/2-Cross_W_40/2+Cross_W_50/2, Cross_L-Cross_L_feed) (Cross_W/2-Cross_L_50/2-Cross_W_40/2+Cross_W_50/2, Cross_L-Cross_L_feed-Cross_W_50/2) (Cross_W/2-Cross_L_50/2, Cross_L-Cross_L_feed-Cross_W_50/2), closed, covered)
  Polyline4 = polyline(z=H, xy: (Cross_W/2+Cross_L_50/2, Cross_L-Cross_L_feed-Cross_W_50/2) (Cross_W/2+Cross_L_50/2+Cross_W_40/2-Cross_W_50/2, Cross_L-Cross_L_feed-Cross_W_50/2) (Cross_W/2+Cross_L_50/2+Cross_W_40/2-Cross_W_50/2, Cross_L-Cross_L_feed) (Cross_W/2+Cross_L_50/2, Cross_L-Cross_L_feed) (Cross_W/2+Cross_L_50/2, Cross_L-Cross_L_feed-Cross_W_50/2), closed, covered)
  series1_1 = rectangle(corner=(Cross_W/2-Cross_L_64/2, Cross_L_feed+Cross_W_50/2, H), x_size=-Cross_W_40, y_size=Cross_L_40)
  series1_2 = rectangle(corner=(Cross_W/2+Cross_L_64/2, Cross_L_feed+Cross_W_50/2, H), x_size=Cross_W_40, y_size=Cross_L_40)
  series2_1 = rectangle(corner=(Cross_W/2-Cross_L_64/2, Cross_L_feed+Cross_W_50/2+Cross_L_40, H), x_size=-Cross_W_64, y_size=Cross_L_64)
  series2_2 = rectangle(corner=(Cross_W/2+Cross_L_64/2, Cross_L_feed+Cross_W_50/2+Cross_L_40, H), x_size=Cross_W_64, y_size=Cross_L_64)
  series3_1 = rectangle(corner=(Cross_W/2-Cross_L_64/2, Cross_L_feed+Cross_W_50/2+Cross_L_40+Cross_L_64, H), x_size=-Cross_W_40, y_size=Cross_L_40)
  series3_2 = rectangle(corner=(Cross_W/2+Cross_L_64/2, Cross_L_feed+Cross_W_50/2+Cross_L_40+Cross_L_64, H), x_size=Cross_W_40, y_size=Cross_L_40)
  Crossover1.unite(feed6, feed7, feed5, parallel1..parallel4, Polyline1..Polyline4, series1_1, series1_2, series2_1, series2_2, series3_1, series3_2)
  Crossover1.rotate(axis=Z, angle=-90deg) in RelativeCS1
  Crossover1.move(Hybrid_W/2+Hybrid_L_120/2+Hybrid_W_50-Cross_W/2-Cross_L_50/2-Cross_W_50/2-Cross_W_40/2, Hybrid_L, 0mm) in RelativeCS1
  Crossover2 = Crossover1.duplicate_along_line(step=(0mm, Hybrid_L+Cross_L_50+Cross_W_50+Cross_W_40, 0mm), total=2) in RelativeCS1
  Top_1 = Top.duplicate_mirror(point=(Hybrid_W/2+Hybrid_L_120/2+Hybrid_W_50+Cross_L/2, 2*Hybrid_L+Cross_W_40+Cross_W_50+Cross_L_50, 0mm), normal=(1mm, 0mm, 0mm))
  Hybrid1 [copper] = rectangle(corner=(Hybrid_W/2-Hybrid_L_120/2, 0mm, H), x_size=-Hybrid_W_50, y_size=Hybrid_L_feed+Hybrid_W_120/2)
  feed2 = rectangle(corner=(Hybrid_W/2-Hybrid_L_120/2, Hybrid_L, H), x_size=-Hybrid_W_50, y_size=-Hybrid_L_feed-Hybrid_W_120/2)
  feed3 = rectangle(corner=(Hybrid_W/2+Hybrid_L_120/2, Hybrid_L, H), x_size=Hybrid_W_50, y_size=-Hybrid_L_feed-Hybrid_W_120/2)
  feed4 = rectangle(corner=(Hybrid_W/2+Hybrid_L_120/2, 0mm, H), x_size=Hybrid_W_50, y_size=Hybrid_L_feed+Hybrid_W_120/2)
  parallel5 = rectangle(corner=(Hybrid_W/2-Hybrid_L_120/2, Hybrid_L_feed, H), x_size=Hybrid_L_120, y_size=Hybrid_W_120)
  parallel6 = rectangle(corner=(Hybrid_W/2-Hybrid_L_120/2, Hybrid_L_feed+Hybrid_L_50+Hybrid_W_120/2-Hybrid_W_70/2, H), x_size=Hybrid_L_120, y_size=Hybrid_W_70)
  parallel7 = rectangle(corner=(Hybrid_W/2-Hybrid_L_120/2, Hybrid_L_feed+2*Hybrid_L_50, H), x_size=Hybrid_L_120, y_size=Hybrid_W_120)
  series1_3 = rectangle(corner=(Hybrid_W/2-Hybrid_L_120/2, Hybrid_L_feed+Hybrid_W_120/2, H), x_size=-Hybrid_W_50, y_size=Hybrid_L_50)
  series1_4 = rectangle(corner=(Hybrid_W/2+Hybrid_L_120/2, Hybrid_L_feed+Hybrid_W_120/2, H), x_size=Hybrid_W_50, y_size=Hybrid_L_50)
  series2_3 = rectangle(corner=(Hybrid_W/2-Hybrid_L_120/2, Hybrid_L_feed+Hybrid_W_120/2+Hybrid_L_50, H), x_size=-Hybrid_W_50, y_size=Hybrid_L_50)
  series2_4 = rectangle(corner=(Hybrid_W/2+Hybrid_L_120/2, Hybrid_L_feed+Hybrid_W_120/2+Hybrid_L_50, H), x_size=Hybrid_W_50, y_size=Hybrid_L_50)
  Hybrid1.unite(feed2, feed3, feed4, parallel5, parallel6, parallel7, series1_3, series1_4, series2_3, series2_4)
  Hybrid2 = Hybrid1.duplicate_along_line(step=(0mm, Hybrid_L+Cross_L_50+Cross_W_50+Cross_W_40, 0mm), total=2)
  Hybrid3 = Hybrid1.duplicate_along_line(step=(Cross_L+Hybrid_L_120+2*Hybrid_W_50, 0mm, 0mm), total=2)
  Hybrid4 = Hybrid2.duplicate_along_line(step=(Cross_L+Hybrid_L_120+2*Hybrid_W_50, 0mm, 0mm), total=2)
  Hybrid1.unite(Hybrid2, Hybrid3, Hybrid4, Phaser45_down, Phaser45_top, Top, Top_1, Bend_1..Bend_8, Crossover1, Crossover2, Feed_5..Feed_8)
  Patch1 = rectangle(corner=(Wa/2-Wp/2, La/2-Lp/2, H), x_size=Wp, y_size=Lp)
  cut = rectangle(corner=(Wa/2-S/2, La/2-Lp/2, H), x_size=S, y_size=depth)
  Patch1.subtract(cut)
  Rectangle1 = rectangle(corner=(Wa/2-W_50/2, 0mm, H), x_size=W_50, y_size=3*hg+depth)
  Patch1.unite(Rectangle1)
  Patch1.move(Hybrid_W/2-Hybrid_L_120/2-2*exten_W_50-2*exten_c-Wa/2-W_50/2, Hybrid_L+2*Cross_W_50+2*Cross_W_40+2*Cross_L_50+Hybrid_L+L_feed5, 0)
  Patch2 = Patch1.duplicate_along_line(step=(2*exten_c+exten_W_50+Hybrid_L_120+2*Hybrid_W_50, 0mm, 0mm), total=2)
  Patch3 = Patch1.duplicate_along_line(step=(2*exten_c+exten_W_50+Hybrid_L_120+3*Hybrid_W_50+Cross_L, 0mm, 0mm), total=2)
  Patch4 = Patch1.duplicate_along_line(step=(4*exten_c+3*exten_W_50+2*Hybrid_L_120+4*Hybrid_W_50+Cross_L, 0mm, 0mm), total=2)
  Hybrid1.unite(Patch1..Patch4)
  Hybrid1.thicken(0.017mm)
boundaries and excitations:
  PerfE1: Perfect E Objects=Ground
  Rad1: Radiation Objects=Box2
  1: Lumped Port Faces=Port1.face Modes{Mode1{IntLine{middle of Port1.edge(z opposite corner) -> middle of Port1.edge(z at corner)} CharImp=Zpi RenormImp=50ohm}} Impedance=50ohm
  2: Lumped Port Objects=Port2 Modes{Mode1{IntLine{middle of Port2.edge(z opposite corner) -> middle of Port2.edge(z at corner)} CharImp=Zpi RenormImp=50ohm}} Impedance=50ohm
  3: Lumped Port Objects=Port3 Modes{Mode1{IntLine{middle of Port3.edge(z opposite corner) -> middle of Port3.edge(z at corner)} CharImp=Zpi RenormImp=50ohm}} Impedance=50ohm
  4: Lumped Port Objects=Port4 Modes{Mode1{IntLine{middle of Port4.edge(z opposite corner) -> middle of Port4.edge(z at corner)} CharImp=Zpi RenormImp=50ohm}} Impedance=50ohm
setups:
  Setup1: HfssDriven Frequency=5GHz MaxDeltaS=0.02 MaximumPasses=25 MinimumPasses=1 MinimumConvergedPasses=1 PercentRefinement=30 BasisOrder=1 PortAccuracy=2
    sweep Sweep: 4GHz to 6GHz step 0.01GHz; Type=Fast SaveFields
source amplitudes:
  1:1: 1W 0deg
  2:1, 3:1, 4:1: 0W 0deg
optimetrics:
  ParametricSetup1: Parametric disabled Sim._Setups=[Setup1]
    sweep L_feed5: LIN 2mm 8mm 0.25mm
output variables:
  phase_diff_5_6 = ang_deg(S(5,1))-ang_deg(S(6,1))
  phase_diff_6_7 = ang_deg(S(6,1))-ang_deg(S(7,1))
  phase_diff_7_8 = ang_deg(S(7,1))-ang_deg(S(8,1))
reports:
  S-Parameters: dB(S(1,1)), dB(S(2,1)), dB(S(3,1)), dB(S(4,1)) vs Freq on Setup1 : Sweep; markers MX1 at x=5.0029718e+09, MY1 at y=-14.975
  Insertion Loss: dB(S(5,1)), dB(S(6,1)), dB(S(7,1)), dB(S(8,1)) vs Freq on Setup1 : Sweep; markers MX1 at x=5.0029718e+09
  S Parameter Plot 3: ang_deg(S(5,1)), ang_deg(S(6,1)), ang_deg(S(7,1)), ang_deg(S(8,1)) vs Freq on Setup1 : Sweep; markers MX1 at x=5e+09
  Output Variables Plot 1: phase_diff_5_6, phase_diff_6_7, phase_diff_7_8 vs Freq on Setup1 : Sweep; markers MX1 at x=5e+09
  S Parameter Plot 4: ang_deg(S(2,1)) vs Freq on Setup1 : Sweep [L_feed5=all]; markers MX1 at x=4.9999383e+09

design Crossover (Circuit)
options: SParamCircuitDef IntegrationMethod=FFT
components:
  A52 = MS_TRL(W=1.76772mm P=5mm)
  A1 = MS_TRL(W=1.76772mm P=8.95112mm)
  A2 = MS_TEEC(W1=2.4943mm W2=1.76772mm W3=1.76772mm)
  A3 = MS_TRL(W=1.76772mm P=5mm)
  A6 = MS_TRL(W=2.4943mm P=8.81112mm)
  A7 = MS_TEEC(W1=1.15236mm W2=2.4943mm W3=1.15236mm)
  A8 = MS_TRL(W=1.15236mm P=8.95112mm)
  A9 = MS_TEEC(W1=2.4943mm W2=1.15236mm W3=1.15236mm)
  A10 = MS_TRL(W=2.4943mm P=8.81112mm)
  A5 = MS_TRL(W=2.4943mm P=8.81112mm)
  A4 = MS_TRL(W=2.4943mm P=8.81112mm)
  A11 = MS_TRL(W=1.15236mm P=9.11693mm)
  A12 = MS_TEEC(W1=2.4943mm W2=1.15236mm W3=1.15236mm)
  A13 = MS_TRL(W=1.15236mm P=8.95112mm)
  A14 = MS_TEEC(W1=1.15236mm W2=2.4943mm W3=1.15236mm)
  A15 = MS_TRL(W=1.15236mm P=9.11693mm)
  A16 = MS_TEEC(W1=2.4943mm W2=1.76772mm W3=1.76772mm)
  A17 = MS_TEEC(W1=1.76772mm W2=2.4943mm W3=1.76772mm)
  A18 = MS_TRL(W=1.76772mm P=8.95112mm)
  A19 = MS_TRL(W=1.76772mm P=5mm)
  A20 = MS_TRL(W=1.76772mm P=5mm)
  A21 = MS_TEEC(W1=1.76772mm W2=2.4943mm W3=1.76772mm)
  port Port1 pnum=1 rz=50ohm iz=0ohm noisetemp=16.85 noisetemporig=16.85cel
  port Port2 pnum=2 rz=50ohm iz=0ohm noisetemp=16.85 noisetemporig=16.85cel
  port Port3 pnum=3 rz=50ohm iz=0ohm noisetemp=16.85 noisetemporig=16.85cel
  port Port4 pnum=4 rz=50ohm iz=0ohm noisetemp=16.85 noisetemporig=16.85cel
nets:
  net_20: A52.1, A21.0
  net_21: A1.1, A21.2
  net_22: A1.0, A2.2
  net_23: A2.1, A3.1
  net_26: A4.1, A16.0
  net_27: A6.0, A2.0
  net_28: A5.1, A17.1
  net_29: A7.1, A6.1
  net_30: A7.2, A8.0
  net_31: A18.0, A17.2
  net_32: A9.2, A8.1
  net_33: A10.0, A21.1
  net_34: A10.1, A9.0
  net_35: A11.0, A7.0
  net_36: A5.0, A12.0
  net_37: A11.1, A12.1
  net_38: A12.2, A13.0
  net_39: A14.1, A4.0
  net_40: A14.2, A13.1
  net_41: A9.1, A15.0
  net_42: A14.0, A15.1
  net_43: A16.2, A18.1
  net_44: A16.1, A19.0
  net_45: A20.0, A17.0
  Port1: A52.0
  Port2: A19.1
  Port3: A20.1
  Port4: A3.0
setups:
  LinearFrequency: LinearFrequencyData(false, 0.1, false, "", false) SweepDefinition{Variable=F Data="LIN 3GHz 7GHz 0.005GHz"}
reports:
  S-Parameters: dB(S(Port1,Port1)), dB(S(Port2,Port1)), dB(S(Port3,Port1)), dB(S(Port4,Port1)) vs F on LinearFrequency : LinearFrequency; markers MX1 at x=5.0263158e+09, MY1 at y=-20
  S Parameter Plot 1: ang_deg(S(Port3,Port1)) vs F on LinearFrequency : LinearFrequency; markers MX1 at x=4.998513e+09

design Hybrid_WB (Circuit)
options: SParamCircuitDef IntegrationMethod=FFT
components:
  A2 = MS_TRL(W=1.76772mm P=5mm)
  A1 = MS_TRL(W=1.76772mm P=5mm)
  A10 = MS_TRL(W=0.24287mm P=9.55345mm)
  A11 = MS_TRL(W=1.76772mm P=8.95112mm)
  A4 = MS_TRL(W=1.76772mm P=8.95112mm)
  A8 = MS_TRL(W=0.95079mm P=9.55345mm)
  A9 = MS_TRL(W=1.76772mm P=8.95112mm)
  A12 = MS_TRL(W=1.76772mm P=8.95112mm)
  A15 = MS_TRL(W=0.24287mm P=9.55345mm)
  A16 = MS_TRL(W=1.76772mm P=5mm)
  A17 = MS_TRL(W=1.76772mm P=5mm)
  A53 = MS_TEEC(W1=1.76772mm W2=1.76772mm W3=0.24287mm)
  A54 = MS_TEEC(W1=1.76772mm W2=1.76772mm W3=0.95079mm)
  A55 = MS_TEEC(W1=1.76772mm W2=1.76772mm W3=0.24287mm)
  A56 = MS_TEEC(W2=1.76772mm W1=1.76772mm W3=0.24287mm)
  A3 = MS_TEEC(W1=1.76772mm W2=1.76772mm W3=0.95079mm)
  A5 = MS_TEEC(W1=1.76772mm W2=1.76772mm W3=0.24287mm)
  port Port1 pnum=1 rz=50ohm iz=0ohm noisetemp=16.85 noisetemporig=16.85cel
  port Port2 pnum=2 rz=50ohm iz=0ohm noisetemp=16.85 noisetemporig=16.85cel
  port Port3 pnum=3 rz=50ohm iz=0ohm noisetemp=16.85 noisetemporig=16.85cel
  port Port4 pnum=4 rz=50ohm iz=0ohm noisetemp=16.85 noisetemporig=16.85cel
nets:
  net_29: A2.1, A53.0
  net_30: A53.1, A11.0
  net_31: A10.1, A53.2
  net_32: A11.1, A54.0
  net_33: A9.0, A54.1
  net_34: A8.1, A54.2
  net_35: A55.0, A9.1
  net_36: A55.1, A16.0
  net_37: A55.2, A15.1
  net_38: A56.0, A4.0
  net_39: A56.1, A1.1
  net_40: A10.0, A56.2
  net_41: A3.0, A12.0
  net_42: A3.1, A4.1
  net_43: A8.0, A3.2
  net_44: A17.0, A5.0
  net_45: A5.1, A12.1
  net_46: A15.0, A5.2
  Port1: A2.0
  Port2: A16.1
  Port3: A17.1
  Port4: A1.0
setups:
  LinearFrequency: LinearFrequencyData(false, 0.1, false, "", false) SweepDefinition{Variable=F Data="LIN 3GHz 7GHz 0.005GHz"}
output variables:
  phase_diff = abs((mod(abs(cang_rad(S(2,1))-cang_rad(S(3,1))),pi)-(pi/2))*180/pi)
  PortGainDiff = abs(dB(S(Port2,Port1))-dB(S(Port3,Port1)))
reports:
  S-Parameters: dB(S(Port1,Port1)), dB(S(Port2,Port1)), dB(S(Port3,Port1)), dB(S(Port4,Port1)) vs F on LinearFrequency : LinearFrequency; markers MX1 at x=5.0014981e+09, MY1 at y=-14
  Port Gain Difference: PortGainDiff vs F on LinearFrequency : LinearFrequency; markers m1 at 5GHz, MY1 at y=0.5
  Phase Error: phase_diff vs F on LinearFrequency : LinearFrequency; markers m1 at 5GHz, MY1 at y=2

design Butler_Matrix (Circuit)
options: SParamCircuitDef IntegrationMethod=FFT
components:
  U476 = Hybrid_WB1()
  U477 = Hybrid_WB1()
  U478 = Hybrid_WB1()
  U479 = Hybrid_WB1()
  U481 = Crossover1()
  U482 = Crossover1()
  A483 = MS_BENDC(W2=1.76772mm W1=1.76772mm)
  A1 = MS_BENDC(W2=1.76772mm W1=1.76772mm)
  A2 = MS_BENDC(W2=1.76772mm W1=1.76772mm)
  A3 = MS_BENDC(W2=1.76772mm W1=1.76772mm)
  A4 = MS_BENDC(W2=1.76772mm W1=1.76772mm)
  A5 = MS_BENDC(W2=1.76772mm W1=1.76772mm)
  A6 = MS_BENDC(W2=1.76772mm W1=1.76772mm)
  A7 = MS_BENDC(W2=1.76772mm W1=1.76772mm)
  A8 = MS_BENDC(W2=1.76772mm W1=1.76772mm)
  A9 = MS_BENDC(W2=1.76772mm W1=1.76772mm)
  A511 = MS_TRL(W=1.76772mm P=7.2mm)
  A10 = MS_TRL(W=1.76772mm P=7.2mm)
  A11 = MS_TRL(W=1.76772mm P=7.2mm)
  A12 = MS_TRL(W=1.76772mm P=7.2mm)
  A13 = MS_BENDC(W2=1.76772mm W1=1.76772mm)
  A14 = MS_BENDC(W2=1.76772mm W1=1.76772mm)
  A529 = MS_TRL(W=1.76772mm P=9.6777mm)
  A15 = MS_BENDC(W2=1.76772mm W1=1.76772mm)
  A16 = MS_BENDC(W2=1.76772mm W1=1.76772mm)
  A17 = MS_TRL(W=1.76772mm P=9.6777mm)
  A539 = MS_TRL(W=1.76772mm P=8.95112mm)
  A18 = MS_TRL(W=1.76772mm P=8.95112mm)
  A19 = MS_TRL(W=1.76772mm P=22.16376mm)
  A20 = MS_TRL(W=1.76772mm P=22.16376mm)
  A21 = MS_BENDC(W2=1.76772mm W1=1.76772mm)
  A22 = MS_BENDC(W2=1.76772mm W1=1.76772mm)
  port Port1 pnum=1 rz=50ohm iz=0ohm noisetemp=16.85 noisetemporig=16.85cel
  port Port2 pnum=2 rz=50ohm iz=0ohm noisetemp=16.85 noisetemporig=16.85cel
  port Port3 pnum=3 rz=50ohm iz=0ohm noisetemp=16.85 noisetemporig=16.85cel
  port Port4 pnum=4 rz=50ohm iz=0ohm noisetemp=16.85 noisetemporig=16.85cel
  port Port5 pnum=5 rz=50ohm iz=0ohm noisetemp=16.85 noisetemporig=16.85cel
  port Port6 pnum=6 rz=50ohm iz=0ohm noisetemp=16.85 noisetemporig=16.85cel
  port Port7 pnum=7 rz=50ohm iz=0ohm noisetemp=16.85 noisetemporig=16.85cel
  port Port8 pnum=8 rz=50ohm iz=0ohm noisetemp=16.85 noisetemporig=16.85cel
nets:
  net_51: U481.3, A483.1
  net_52: A483.0, U476.2
  net_53: U482.3, A1.1
  net_54: U477.2, A1.0
  net_55: U481.0, A2.0
  net_56: U481.2, A3.0
  net_57: U481.1, A4.1
  net_58: A4.0, U479.0
  net_59: A3.1, U478.1
  net_60: U477.Port2, A2.1
  net_61: U482.2, A5.0
  net_62: U479.1, A5.1
  net_63: A6.1, U476.1
  net_64: U477.0, A7.0
  net_65: U478.2, A8.0
  net_66: U479.Port2, A9.1
  net_67: A8.1, A511.0
  net_68: A6.0, A10.1
  net_69: A7.1, A11.1
  net_70: A12.0, A9.0
  net_71: A511.1, A13.1
  net_72: A12.1, A14.0
  net_73: A13.0, A529.0
  net_74: A14.1, A529.1
  net_75: A15.0, A10.0
  net_76: A16.1, A11.0
  net_77: A15.1, A17.0
  net_78: A17.1, A16.0
  net_81: U477.1, A19.0
  net_82: U479.2, A20.0
  net_83: U482.0, A21.0
  net_84: U482.1, A22.1
  net_85: A18.0, A22.0
  net_86: A21.1, A539.0
  Port1: U476.0
  Port2: U476.Port2
  Port3: U478.0
  Port4: U478.Port2
  Port5: A19.1
  Port6: A539.1
  Port7: A18.1
  Port8: A20.1
setups:
  LinearFrequency: LinearFrequencyData(false, 0.1, false, "", false) SweepDefinition{Variable=F Data="LIN 3GHz 7GHz 0.005GHz"}
reports:
  S-Parameters: dB(S(Port1,Port1)), dB(S(Port2,Port1)), dB(S(Port3,Port1)), dB(S(Port4,Port1)) vs F on LinearFrequency : LinearFrequency; markers MX1 at x=5.005997e+09, MY1 at y=-14
  Insertion Loss: dB(S(Port5,Port1)), dB(S(Port6,Port1)), dB(S(Port7,Port1)), dB(S(Port8,Port1)) vs F on LinearFrequency : LinearFrequency; markers MX1 at x=5.005997e+09

design Hybrid_WB1 (Circuit)
options: SParamCircuitDef IntegrationMethod=FFT
components:
  A2 = MS_TRL(W=1.76772mm P=5mm)
  A1 = MS_TRL(W=1.76772mm P=5mm)
  A10 = MS_TRL(W=0.24287mm P=9.55345mm)
  A11 = MS_TRL(W=1.76772mm P=8.95112mm)
  A4 = MS_TRL(W=1.76772mm P=8.95112mm)
  A8 = MS_TRL(W=0.95079mm P=9.55345mm)
  A9 = MS_TRL(W=1.76772mm P=8.95112mm)
  A12 = MS_TRL(W=1.76772mm P=8.95112mm)
  A15 = MS_TRL(W=0.24287mm P=9.55345mm)
  A16 = MS_TRL(W=1.76772mm P=5mm)
  A17 = MS_TRL(W=1.76772mm P=5mm)
  A53 = MS_TEEC(W1=1.76772mm W2=1.76772mm W3=0.24287mm)
  A54 = MS_TEEC(W1=1.76772mm W2=1.76772mm W3=0.95079mm)
  A55 = MS_TEEC(W1=1.76772mm W2=1.76772mm W3=0.24287mm)
  A56 = MS_TEEC(W2=1.76772mm W1=1.76772mm W3=0.24287mm)
  A3 = MS_TEEC(W1=1.76772mm W2=1.76772mm W3=0.95079mm)
  A5 = MS_TEEC(W1=1.76772mm W2=1.76772mm W3=0.24287mm)
  port Port1 pnum=1 rz=50ohm iz=0ohm noisetemp=16.85 noisetemporig=16.85cel
  port Port2 pnum=2 rz=50ohm iz=0ohm noisetemp=16.85 noisetemporig=16.85cel
  port Port3 pnum=3 rz=50ohm iz=0ohm noisetemp=16.85 noisetemporig=16.85cel
  port Port4 pnum=4 rz=50ohm iz=0ohm noisetemp=16.85 noisetemporig=16.85cel
nets:
  net_29: A53.0, A2.1
  net_30: A53.1, A11.0
  net_31: A53.2, A10.1
  net_32: A54.0, A11.1
  net_33: A54.1, A9.0
  net_34: A8.1, A54.2
  net_35: A55.0, A9.1
  net_36: A16.0, A55.1
  net_37: A55.2, A15.1
  net_38: A56.0, A4.0
  net_39: A56.1, A1.1
  net_40: A56.2, A10.0
  net_41: A3.0, A12.0
  net_42: A4.1, A3.1
  net_43: A3.2, A8.0
  net_44: A5.0, A17.0
  net_45: A12.1, A5.1
  net_46: A5.2, A15.0
  Port1: A2.0
  Port2: A16.1
  Port3: A17.1
  Port4: A1.0
setups:
  LinearFrequency: LinearFrequencyData(false, 0.1, false, "", false) SweepDefinition{Variable=F Data="LIN 3GHz 7GHz 0.005GHz"}
output variables:
  phase_diff = abs((mod(abs(cang_rad(S(2,1))-cang_rad(S(3,1))),pi)-(pi/2))*180/pi)
  PortGainDiff = abs(dB(S(Port2,Port1))-dB(S(Port3,Port1)))

design Crossover1 (Circuit)
options: SParamCircuitDef IntegrationMethod=FFT
components:
  A52 = MS_TRL(W=1.76772mm P=5mm)
  A1 = MS_TRL(W=1.76772mm P=8.95112mm)
  A2 = MS_TEEC(W1=2.4943mm W2=1.76772mm W3=1.76772mm)
  A3 = MS_TRL(W=1.76772mm P=5mm)
  A6 = MS_TRL(W=2.4943mm P=8.81112mm)
  A7 = MS_TEEC(W1=1.15236mm W2=2.4943mm W3=1.15236mm)
  A8 = MS_TRL(W=1.15236mm P=8.95112mm)
  A9 = MS_TEEC(W1=2.4943mm W2=1.15236mm W3=1.15236mm)
  A10 = MS_TRL(W=2.4943mm P=8.81112mm)
  A5 = MS_TRL(W=2.4943mm P=8.81112mm)
  A4 = MS_TRL(W=2.4943mm P=8.81112mm)
  A11 = MS_TRL(W=1.15236mm P=9.11693mm)
  A12 = MS_TEEC(W1=2.4943mm W2=1.15236mm W3=1.15236mm)
  A13 = MS_TRL(W=1.15236mm P=8.95112mm)
  A14 = MS_TEEC(W1=1.15236mm W2=2.4943mm W3=1.15236mm)
  A15 = MS_TRL(W=1.15236mm P=9.11693mm)
  A16 = MS_TEEC(W1=2.4943mm W2=1.76772mm W3=1.76772mm)
  A17 = MS_TEEC(W1=1.76772mm W2=2.4943mm W3=1.76772mm)
  A18 = MS_TRL(W=1.76772mm P=8.95112mm)
  A19 = MS_TRL(W=1.76772mm P=5mm)
  A20 = MS_TRL(W=1.76772mm P=5mm)
  A21 = MS_TEEC(W1=1.76772mm W2=2.4943mm W3=1.76772mm)
  port Port1 pnum=1 rz=50ohm iz=0ohm noisetemp=16.85 noisetemporig=16.85cel
  port Port2 pnum=2 rz=50ohm iz=0ohm noisetemp=16.85 noisetemporig=16.85cel
  port Port3 pnum=3 rz=50ohm iz=0ohm noisetemp=16.85 noisetemporig=16.85cel
  port Port4 pnum=4 rz=50ohm iz=0ohm noisetemp=16.85 noisetemporig=16.85cel
nets:
  net_20: A21.0, A52.1
  net_21: A21.2, A1.1
  net_22: A1.0, A2.2
  net_23: A3.1, A2.1
  net_26: A4.1, A16.0
  net_27: A2.0, A6.0
  net_28: A17.1, A5.1
  net_29: A6.1, A7.1
  net_30: A7.2, A8.0
  net_31: A17.2, A18.0
  net_32: A8.1, A9.2
  net_33: A21.1, A10.0
  net_34: A10.1, A9.0
  net_35: A11.0, A7.0
  net_36: A5.0, A12.0
  net_37: A11.1, A12.1
  net_38: A13.0, A12.2
  net_39: A4.0, A14.1
  net_40: A13.1, A14.2
  net_41: A9.1, A15.0
  net_42: A14.0, A15.1
  net_43: A16.2, A18.1
  net_44: A16.1, A19.0
  net_45: A17.0, A20.0
  Port1: A52.0
  Port2: A19.1
  Port3: A20.1
  Port4: A3.0
setups:
  LinearFrequency: LinearFrequencyData(false, 0.1, false, "", false) SweepDefinition{Variable=F Data="LIN 3GHz 7GHz 0.005GHz"}
